;;-----------------------------------------------------------------------------
;; Bindkeys for 'Schematics'
;; Inherited by:
;;             * ACS-Schematics
;;             * Diva
;;             * NC-Verilog
;;             * Other-Schematic
;;             * Schematics XL
;;             * Simulation
;;             * Sparks-Mismatch-Schematics
;;             * Sparks-MismatchResult-Schematics
;;             * Sparks-Result-Schematics
;;             * Sparks-Schematics
;;             * Sparks-Slider
;;             * Spectre-Schematic
;;             * UltraSim-Schematic
;;             * VHDL Toolbox
;;             * adegxl-schematic
;;             * adexl-schematic
;;             * parasitics-Schematic
;;             * sip-schematic-packaging
;;             * sip-schematic-testbench
;;-----------------------------------------------------------------------------
hiSetBindKeys( "Schematics XL" list(
    list("<DrawThru1>"	"schDirectEdit(1)"	"geSingleSelectBox()")
    list("<DrawThru3>"	"hiZoomIn()"	"hiZoomIn()")
    list("<Key>#"	"hiToggleAnchorMagnifier()")
    list("<Key>'"	"hiUpdateMagOptions()")
    list("<Key>."	"hiToggleMagnifier()")
    list("<Key>2"	"deInstallApp(getCurrentWindow() \"analogArtist-Schematic\")")
    list("<Key>3"	"ddsOpenLibManager()")
    list("<Key>4"	"setLibName()")
    list("<Key>5"	"toggleNetHighlight") ;"schHiRouteFlightLine()"()
;    list("<Key>6"	"schHiOpenCellView()" "hiRegTimer(\"sprintf(nil \"deOpenForm->deLibName->value =%L\" hiGetCurrentWindow()->cellView->libName)\" 1)")
    list("<Key>6"	"customizeOpen()")
    list("<Key>7"	"customizeNew()")
    list("<Key>8"	"schHiHiliteLabel(\"instance\" \"on\")")
   ; list("<Key>9"	"geAddNetProbe()")
    list("<Key>0"	"geEnterDeleteNetProbe()")
    list("<Key>9"	"geEnterAddNetProbe()")
    list("<Key>1"	"geDeleteAllProbe(getCurrentWindow() t)")
;    list("<Key>="	"hiGetCurrentWindow()->drawGridOn=t 				hiGetCurrentWindow()->drawDottedGridOn=nil ")
    list("<Key>-"	"hiZoomRelativeScale(getCurrentWindow() 0.5)")
    list("<Key>="	"hiZoomRelativeScale(getCurrentWindow() 2)")
    list("<Key>A"	"geSingleSelectPoint()")
    ;list("<Key>B"	"schHiCreateBlockInst()")
    list("<Key>B"	"change_name()")
    list("<Key>BackSpace"	"schHiDelete()"	"deletePoint()")
    list("<Key>C"	"schHiCopy()")
;    list("<Key>D"	"geSubSelectPoint()")
     list("<Key>S"	"geSubSelectPoint()")
    list("<Key>D"	"schHiDelete()")
   list("<Key>Delete"	"schHiDelete()")
    list("<Key>Down"	"geScroll(nil \"s\" nil)")
    list("<Key>E"	"schHiDescendRead()")
    list("<Key>Escape"	""	"cancelEnterFun()")
    list("<Key>F"	"hiZoomAbsoluteScale(getCurrentWindow() 0.9)")
    list("<Key>F1"	"hiHelp('window deGetAppInfo(deGetEditViewType(hiGetCurrentWindow()))->appName)")
    list("<Key>F10"	"setTID()")
    list("<Key>F11"	"setTI4()")
    list("<Key>F12"	"setams()")
;    list("<Key>F11"	"deToggleAssistants()")
    list("<Key>F2"	"schHiSaveCellView()")
    list("<Key>F3"	""	"hiToggleEnterForm()")
    list("<Key>F4"	"geTogglePartialSelect()")
    list("<Key>F5"	"hiRaiseWindow(if(sevSession(hiGetCurrentWindow()) sevSession(hiGetCurrentWindow())->window  hiGetCIWindow()))")
    ;list("<Key>F5"	"hiDeiconifyWindow(if(sevSession(hiGetCurrentWindow()) sevSession(hiGetCurrentWindow())->window  hiGetCIWindow()))")
    list("<Key>F6"	"hiRedraw()")
    list("<Key>G"	"curr_win_toggle()")
    list("<Key>h" "schHiEditInPlace()")
    ;list("<Key>H"	"schHiHiliteLabel(\"wire\" \"on\")")
    list("<Key>I"	"customizeInsert()")
    list("<Key>J"	"if(ggss() addNetsNOCONN() addgnds())")
    list("<Key>L"	"schHiCreateWireLabel()")
    list("<Key>Left"	"geScroll(nil \"w\" nil)")
    list("<Key>M"	"schHiStretch()")
    list("<Key>N"	"schHiCreateNoteShape()")
    list("<Key>O"	"schHiDisplayOptions()")
    list("<Key>P"	"schHiCreatePin()")
    list("<Key>Q"	"schHiObjectProperty()"	"schHiObjectProperty()")
    list("<Key>R"	"schHiRotate()"	"schSetEnv(\"rotate\" t)")
    list("<Key>Return"	"hiPrevWinView(hiGetCurrentWindow())")
    list("<Key>Right"	"geScroll(nil \"e\" nil)")
    list("<Key>S"	"schHiFind()")
    list("<Key>T"	"FT_cppLibsReferenced()")
    list("<Key>Tab"	"hiPan()")
    list("<Key>U"	"hiUndo()")
    list("<Key>Up"	"geScroll(nil \"n\" nil)")
    list("<Key>V"	"_schHiToggleLabels(\"termLabels\")")
    list("<Key>W"	"schHiCreateWire(0.0)")
    list("<Key>X"	"schHiCheck(\"run\")")
    list("<Key>Y"	"UCRelMove()")
    list("<Key>Z"	"hiZoomIn()")
    list("<Key>["	"hiZoomRelativeScale(getCurrentWindow() 0.8)")
    list("<Key>]"	"hiZoomRelativeScale(getCurrentWindow() 1.25)")
    list("<Key>space"	"schHiCreateWireStubs()")
    list("Ctrl Alt<Key>C"	"schHiViewToView()")
    list("Ctrl Alt<Key>J" "gotoPsfDir()")       ; get current netlist directory  .../TIspiceD/schematic/netlist
    list("Ctrl Alt<key>F12"	"schHiCheckAndSave() sevStopEngine(sevSession(getCurrentWindow()))")
    list("Ctrl Alt<Key>S"	"schSetEnv(\"sideways\" t)")
    list("Ctrl Alt<Key>W"	"schSetEnv(\"upsideDown\" t)")
    list("Ctrl Alt<Key>O"	"CCSSchSnapToggle()")
    list("Ctrl Alt<Key>P"	"plotXL()")
    list("Ctrl Alt<Key>Q"	"showCos()")
    list("Ctrl Alt<Key>V"	"schObjPropForm->paramView->value=\"veriloga\"")
    list("Ctrl Shift<Btn1Down>"	"hiZoomInMagnifier(hiGetCurrentWindow())")
    list("Ctrl Shift<Btn2Down>"	"hiZoomOutMagnifier(hiGetCurrentWindow())")
    list("Ctrl Shift<Btn4Down>"	"hiScaleMagnifier(1.25)")
    list("Ctrl Shift<Btn5Down>"	"hiScaleMagnifier(0.80)")
    list("Ctrl Shift<Key>Down"	"hiScaleMagnifier(0.80)")
    list("Ctrl Shift<Key>Up"	"hiScaleMagnifier(1.25)")
    list("Ctrl Shift<Key>7"	"customizeNew(\"Xsim_\")")
    list("Ctrl Shift<Key>A"	"hiScaleMagnifier(1.25)")
    list("Ctrl Shift<Key>B"	"_schHiChangeEditMode(\"a\")")
    list("Ctrl Shift<Key>C"	"schHiViewToView()")
    list("Ctrl Shift<Key>D"	"COCELL()")
    list("Ctrl Shift<Key>E"	"schHiReturnToTop()")
    list("Ctrl Shift<Key>F"	"if(sevSession(hiGetCurrentWindow())->window hiCloseWindow(sevSession(hiGetCurrentWindow())->window) hiCloseWindow(hiGetCurrentWindow()))")
    list("Ctrl Shift<Key>G"    "_sevView3stepLog(sevEnvironment(sevSession(getCurrentWindow())))"      "hiScrollWindowBottom(hiGetCurrentWindow())")
    list("Ctrl Shift<Key>F10"	"setTID_only()")
    list("Ctrl Shift<key>F12"	"schHiCheckAndSave() sevNetlistFile(sevSession(getCurrentWindow()) 'recreate) sevNetlistAndRun(sevSession(getCurrentWindow()))")
;    list("Ctrl Shift<key>F12"	"sevNetlistAndRun(sevSession(getCurrentWindow()))")
    list("Ctrl Shift<Key>I"	"sevAnnotateResults(sevSession(getCurrentWindow()) 'dcOpPoints)")
    list("Ctrl Shift<Key>J"	"viewIrun()")
    list("Ctrl Shift<Key>K"	"viewNetlistLog()")
    list("Ctrl Shift<Key>L"	"tiPdkPreviewPCellLayout()")
    list("Ctrl Shift<Key>M"	"viewNetlist()")
    list("Ctrl Shift<Key>N"	"sevAnnotateResults(sevSession(getCurrentWindow()) 'dcNodeVoltages)")
    list("Ctrl Shift<Key>O"    "toggleSnapSpacing()")
    list("Ctrl Shift<Key>P"    "sevAnnotateResults(sevSession(getCurrentWindow()) 'componentParameters)")
    list("Ctrl Shift<Key>Q"    "dssOpenVersionMCB()"   "hiiSetCurrentForm('dssOpenVersionForm)")
    list("Ctrl Shift<Key>R"	"_schHiChangeEditMode(\"r\")")
    list("Ctrl Shift<Key>S"	"SosEditorMenuCB(\"SosCheckInItem\")")
    list("Ctrl Shift<Key>V"	"SosEditorMenuCB(\"SosHistoryItem\")")
    list("Ctrl Shift<Key>X"	"SosEditorMenuCB(\"SosCancelCheckOutItem\")")
    list("Ctrl Shift<Key>Z"	"hiNextWinView(hiGetCurrentWindow())")
    list("Ctrl<Btn1Down>"	"mouseSubSelectPt()"	"mouseSubSelectPt()")
    list("Ctrl<Btn4Down>"	"hiZoomInAtMouse()")
    list("Ctrl<Btn5Down>"	"hiZoomOutAtMouse()")
    list("Ctrl<DrawThru1>"	"schDirectEdit(3)"	"geSubSelectBox()")
    list("Ctrl<Key>A"	"geSelectAllFig()")
    ;list("Ctrl<Key>D"	"geDeselectAllFig()")
    list("Ctrl<Key>D"	"CCSToggleDimming()")
    list("Ctrl<Key>E"	"schHiReturn()")
    list("Ctrl<Key>F"	"hiGetCurrentWindow()->stopLevel = 0")
    ;list("Ctrl<Key>F11"	"deToggleToolbars()")

    list("Ctrl<Key>G"	"geHiDeleteMarker()")
    list("Ctrl<Key>M"	"(hiDisplayMenu LVSH_TopMenuNS)")
    list("Ctrl<Key>O"	"schHiGridOptions()")
    list("Ctrl<Key>P"	"schHiPlot()")
    list("Ctrl<Key>Q"	""	"geQuerySelSet()")
    list("Ctrl<Key>R"	""	"schSetEnv(\"upsideDown\" t)")
    list("Ctrl<Key>S"	"_schHiSaveAs()")
    ;list("Ctrl<Key>T"	"schHiZoomToSelSet()")
    list("Ctrl<Key>T"	"set_mypref()")
    list("Ctrl<Key>Tab"	"hiLowerWindow(hiGetCurrentWindow())")
    list("Ctrl<Key>V"	"hiFocusToCIW(hiGetCurrentWindow())")
    list("Ctrl<Key>W"	"hiCloseWindow(getCurrentWindow())")
    list("Ctrl<Key>Z"	"hiZoomRelativeScale(hiGetCurrentWindow() 2.0)")
    list("None<Btn1Down>"	"schSingleSelectPt()"	"mouseAddPt(t)")
    list("None<Btn1Down>(2)"	"schExtendSelectPt()"	"schMouseApplyOrFinish()")
    list("None<Btn2Down>"	"hiCloseWindow(hiGetCurrentWindow())"	"schHiMousePopUp()")
    list("None<Btn3Down>"	"schHiMousePopUp()"	"schCmdOption()")
    list("None<Btn3Down>(2)"	""	"hiToggleEnterForm()")
    list("None<Btn4Down>"	"geScroll(nil \"n\" nil)")
    list("None<Btn5Down>"	"geScroll(nil \"s\" nil)")
    list("Shift<Btn1Down>"	"schAddSelectPt()"	"mouseAddSelectPt()")
    list("Shift<Btn1Down>(2)"	"schExtendSelectPt()")
    list("Shift<Btn2Down>"	""	"schShiftCmdOption()")
    list("Shift<Btn3Down>"	""	"schShiftCmdOption()")
    list("Shift<Btn4Down>"	"geScroll(nil \"w\" nil)")
    list("Shift<Btn5Down>"	"geScroll(nil \"e\" nil)")
    list("Shift<DrawThru1>"	"schDirectEdit(2)"	"geAddSelectBox()")
    list("Shift<DrawThru3>"	"hiZoomOut()"	"hiZoomOut()")
    list("Shift<Key>1"	"load(\"~/myskill.il\")")
    list("Shift<Key>2"	"deInstallApp(getCurrentWindow() \"Schematics XL\")")
    list("Shift<Key>4"	"hiDeiconifyWindow(hiGetCIWindow()) hiRaiseWindow(hiGetCIWindow())")
    list("Shift<Key>5"	"displayMode(\"strip\")")
    list("Shift<Key>6"	"schHiOpenCellView()")
    ;list("Shift<Key>7"	"customizeNewSimCellView()")
    list("Shift<Key>7"	"createSimView()")
    list("Shift<Key>8"	"schHiHiliteLabel(\"instance\" \"off\")")
    list("Shift<Key>;"	"hiGetCurrentWindow()->drawGridOn=t 				hiGetCurrentWindow()->drawDottedGridOn=t ")
    list("Shift<Key>A"	"geSingleSelectBox()")
    list("Shift<Key>C"	"sevOpenCalculator()")
    list("Shift<Key>D"	"geSubSelectBox()")
    list("Shift<Key>E"	"schHiDescendEdit()")
    list("Shift<Key>F"	"hiGetCurrentWindow()->stopLevel = 20")
    list("Shift<Key>K"	"updatePinsFromSymbol(dgcv())")
    list("Shift<Key>F11"	"deToggleAssistants() deToggleToolbars()")
    list("Shift<Key>F10"	"schHiCheckAndSave() TIspiceNetlistAndRun(sevSession(hiGetCurrentWindow()))")
    list("Shift<Key>F12"	"sevNetlistFile(sevSession(getCurrentWindow() 'recreate)) sevNetlistAndRun(sevSession(getCurrentWindow()))")
    list("Shift<Key>F4"	"geToggleAreaSelectOption()")
    list("Shift<key>F6"	"XLCloseDataOpenData()")
    list("Shift<Key>G"	"descend_toggle()")
    list("<Key>h" "schHiEditInPlace()")
    ;list("Shift<Key>H"	"schHiHiliteLabel(\"wire\" \"off\")")
    list("Shift<Key>L"	"schHiCreateNoteLabel()")
    list("Shift<Key>M"	"schHiMove()")
    list("Shift<Key>N"	"schHiCreateNoteLabel()")
    list("Shift<Key>O"	"schHiEditorOptions()")
    list("Shift<Key>Q"	"schHiCellViewProperty()"	"schHiCellViewProperty()")
 ;  list("Shift<Key>R"	""	"schSetEnv(\"sideways\" t)")
    list("Shift<Key>R"	"awvRedisplayWindow(awvGetCurrentWindow())")
    list("Shift<Key>S"	"hiLowerWindow(hiGetCurrentWindow())")
;   list("Shift<Key>S"	"_schHiSave()")
    list("Shift<Key>T"	"schHiTree()")
    list("Shift<Key>U"	"hiRedo()")
    list("Shift<Key>V"	"_deToggleAssistant(\"World View\")")
    list("Shift<Key>W"	"schHiCreateWire(schGetEnv(\"defWideWireWidth\"))")
    list("Shift<Key>X"	"schHiCheckAndSave()")
    list("Shift<Key>Z"	"hiZoomRelativeScale(hiGetCurrentWindow() 0.5)")
    list("Alt Shift<Key>S"	"staticParasiticAnalysis()")
    list("Alt Shift<Key>B"	"addBoth()")
    list("Alt Shift<Key>D"	"addAVDD()")
    list("Alt Shift<Key>V"	"addAVSS()")
    list("Alt Shift<Key>F10"	"TIspiceViewNetlistDirFile(sevSession(hiGetCurrentWindow()) \"TISPICE_OUT\")" "hiRegTimer(\"hiScrollWindowBottom(hiGetCurrentWindow())\" 2)")
)) ;; hiSetBindKeys
;;-----------------------------------------------------------------------------

hiSetBindKeys( "Schematics" list(
    list("<DrawThru1>"	"schDirectEdit(1)"	"geSingleSelectBox()")
    list("<DrawThru3>"	"hiZoomIn()"	"hiZoomIn()")
    list("<Key>#"	"hiToggleAnchorMagnifier()")
    list("<Key>'"	"hiUpdateMagOptions()")
    list("<Key>."	"hiToggleMagnifier()")
    list("<Key>2"	"deInstallApp(getCurrentWindow() \"analogArtist-Schematic\")")
    list("<Key>3"	"ddsOpenLibManager()")
    list("<Key>4"	"setLibName()")
    list("<Key>5"	"toggleNetHighlight") ;"schHiRouteFlightLine()"()
;    list("<Key>6"	"schHiOpenCellView()" "hiRegTimer(\"sprintf(nil \"deOpenForm->deLibName->value =%L\" hiGetCurrentWindow()->cellView->libName)\" 1)")
    list("<Key>6"	"customizeOpen()")
    list("<Key>7"	"customizeNew()")
    list("<Key>8"	"schHiHiliteLabel(\"instance\" \"on\")")
   ; list("<Key>9"	"geAddNetProbe()")
    list("<Key>0"	"geEnterDeleteNetProbe()")
    list("<Key>9"	"geEnterAddNetProbe()")
    list("<Key>1"	"geDeleteAllProbe(getCurrentWindow() t)")
;    list("<Key>="	"hiGetCurrentWindow()->drawGridOn=t 				hiGetCurrentWindow()->drawDottedGridOn=nil ")
    list("<Key>-"	"hiZoomRelativeScale(getCurrentWindow() 0.5)")
    list("<Key>="	"hiZoomRelativeScale(getCurrentWindow() 2)")
    list("<Key>A"	"geSingleSelectPoint()")
    ;list("<Key>B"	"schHiCreateBlockInst()")
    list("<Key>B"	"change_name()")
    list("<Key>BackSpace"	"schHiDelete()"	"deletePoint()")
    list("<Key>C"	"schHiCopy()")
;    list("<Key>D"	"geSubSelectPoint()")
     list("<Key>S"	"geSubSelectPoint()")
    list("<Key>D"	"schHiDelete()")
   list("<Key>Delete"	"schHiDelete()")
    list("<Key>Down"	"geScroll(nil \"s\" nil)")
    list("<Key>E"	"schHiDescendRead()")
    list("<Key>Escape"	""	"cancelEnterFun()")
    list("<Key>F"	"hiZoomAbsoluteScale(getCurrentWindow() 0.9)")
    list("<Key>F1"	"hiHelp('window deGetAppInfo(deGetEditViewType(hiGetCurrentWindow()))->appName)")
    list("<Key>F10"	"setTID()")
    list("<Key>F11"	"setTI4()")
    list("<Key>F12"	"setams()")
;    list("<Key>F11"	"deToggleAssistants()")
    list("<Key>F2"	"schHiSaveCellView()")
    list("<Key>F3"	""	"hiToggleEnterForm()")
    list("<Key>F4"	"geTogglePartialSelect()")
    list("<Key>F5"	"hiRaiseWindow(if(sevSession(hiGetCurrentWindow()) sevSession(hiGetCurrentWindow())->window  hiGetCIWindow()))")
    ;list("<Key>F5"	"hiDeiconifyWindow(if(sevSession(hiGetCurrentWindow()) sevSession(hiGetCurrentWindow())->window  hiGetCIWindow()))")
    list("<Key>F6"	"hiRedraw()")
    list("<Key>G"	"curr_win_toggle()")
    list("<Key>h" "schHiEditInPlace()")
    ;list("<Key>H"	"schHiHiliteLabel(\"wire\" \"on\")")
    list("<Key>I"	"customizeInsert()")
    list("<Key>J"	"if(ggss() addNetsNOCONN() addgnds())")
    list("<Key>L"	"schHiCreateWireLabel()")
    list("<Key>Left"	"geScroll(nil \"w\" nil)")
    list("<Key>M"	"schHiStretch()")
    list("<Key>N"	"schHiCreateNoteShape()")
    list("<Key>O"	"schHiDisplayOptions()")
    list("<Key>P"	"schHiCreatePin()")
    list("<Key>Q"	"schHiObjectProperty()"	"schHiObjectProperty()")
    list("<Key>R"	"schHiRotate()"	"schSetEnv(\"rotate\" t)")
    list("<Key>Return"	"hiPrevWinView(hiGetCurrentWindow())")
    list("<Key>Right"	"geScroll(nil \"e\" nil)")
    list("<Key>S"	"schHiFind()")
    list("<Key>T"	"FT_cppLibsReferenced()")
    list("<Key>Tab"	"hiPan()")
    list("<Key>U"	"hiUndo()")
    list("<Key>Up"	"geScroll(nil \"n\" nil)")
    list("<Key>V"	"_schHiToggleLabels(\"termLabels\")")
    list("<Key>W"	"schHiCreateWire(0.0)")
    list("<Key>X"	"schHiCheck(\"run\")")
    list("<Key>Y"	"UCRelMove()")
    list("<Key>Z"	"hiZoomIn()")
    list("<Key>["	"hiZoomRelativeScale(getCurrentWindow() 0.8)")
    list("<Key>]"	"hiZoomRelativeScale(getCurrentWindow() 1.25)")
    list("<Key>space"	"schHiCreateWireStubs()")
    list("Ctrl Alt<Key>C"	"schHiViewToView()")
    list("Ctrl Alt<Key>J" "gotoPsfDir()")       ; get current netlist directory  .../TIspiceD/schematic/netlist
    list("Ctrl Alt<key>F12"	"schHiCheckAndSave() sevStopEngine(sevSession(getCurrentWindow()))")
    list("Ctrl Alt<Key>S"	"schSetEnv(\"sideways\" t)")
    list("Ctrl Alt<Key>W"	"schSetEnv(\"upsideDown\" t)")
    list("Ctrl Alt<Key>O"	"CCSSchSnapToggle()")
    list("Ctrl Alt<Key>P"	"plotXL()")
    list("Ctrl Alt<Key>Q"	"showCos()")
    list("Ctrl Alt<Key>V"	"schObjPropForm->paramView->value=\"veriloga\"")
    list("Ctrl Shift<Btn1Down>"	"hiZoomInMagnifier(hiGetCurrentWindow())")
    list("Ctrl Shift<Btn2Down>"	"hiZoomOutMagnifier(hiGetCurrentWindow())")
    list("Ctrl Shift<Btn4Down>"	"hiScaleMagnifier(1.25)")
    list("Ctrl Shift<Btn5Down>"	"hiScaleMagnifier(0.80)")
    list("Ctrl Shift<Key>Down"	"hiScaleMagnifier(0.80)")
    list("Ctrl Shift<Key>Up"	"hiScaleMagnifier(1.25)")
    list("Ctrl Shift<Key>7"	"customizeNew(\"Xsim_\")")
    list("Ctrl Shift<Key>A"	"hiScaleMagnifier(1.25)")
    list("Ctrl Shift<Key>B"	"_schHiChangeEditMode(\"a\")")
    list("Ctrl Shift<Key>C"	"schHiViewToView()")
    list("Ctrl Shift<Key>D"	"COCELL()")
    list("Ctrl Shift<Key>E"	"schHiReturnToTop()")
    list("Ctrl Shift<Key>F"	"if(sevSession(hiGetCurrentWindow())->window hiCloseWindow(sevSession(hiGetCurrentWindow())->window) hiCloseWindow(hiGetCurrentWindow()))")
    list("Ctrl Shift<Key>G"    "_sevView3stepLog(sevEnvironment(sevSession(getCurrentWindow())))"      "hiScrollWindowBottom(hiGetCurrentWindow())")
    list("Ctrl Shift<Key>F10"	"setTID_only()")
    list("Ctrl Shift<key>F12"	"schHiCheckAndSave() sevNetlistFile(sevSession(getCurrentWindow()) 'recreate) sevNetlistAndRun(sevSession(getCurrentWindow()))")
;    list("Ctrl Shift<key>F12"	"sevNetlistAndRun(sevSession(getCurrentWindow()))")
    list("Ctrl Shift<Key>I"	"sevAnnotateResults(sevSession(getCurrentWindow()) 'dcOpPoints)")
    list("Ctrl Shift<Key>J"	"viewIrun()")
    list("Ctrl Shift<Key>K"	"viewNetlistLog()")
    list("Ctrl Shift<Key>L"	"tiPdkPreviewPCellLayout()")
    list("Ctrl Shift<Key>M"	"viewNetlist()")
    list("Ctrl Shift<Key>N"	"sevAnnotateResults(sevSession(getCurrentWindow()) 'dcNodeVoltages)")
    list("Ctrl Shift<Key>O"    "toggleSnapSpacing()")
    list("Ctrl Shift<Key>P"    "sevAnnotateResults(sevSession(getCurrentWindow()) 'componentParameters)")
    list("Ctrl Shift<Key>Q"    "dssOpenVersionMCB()"   "hiiSetCurrentForm('dssOpenVersionForm)")
    list("Ctrl Shift<Key>R"	"_schHiChangeEditMode(\"r\")")
    list("Ctrl Shift<Key>S"	"SosEditorMenuCB(\"SosCheckInItem\")")
    list("Ctrl Shift<Key>V"	"SosEditorMenuCB(\"SosHistoryItem\")")
    list("Ctrl Shift<Key>X"	"SosEditorMenuCB(\"SosCancelCheckOutItem\")")
    list("Ctrl Shift<Key>Z"	"hiNextWinView(hiGetCurrentWindow())")
    list("Ctrl<Btn1Down>"	"mouseSubSelectPt()"	"mouseSubSelectPt()")
    list("Ctrl<Btn4Down>"	"hiZoomInAtMouse()")
    list("Ctrl<Btn5Down>"	"hiZoomOutAtMouse()")
    list("Ctrl<DrawThru1>"	"schDirectEdit(3)"	"geSubSelectBox()")
    list("Ctrl<Key>A"	"geSelectAllFig()")
    ;list("Ctrl<Key>D"	"geDeselectAllFig()")
    list("Ctrl<Key>D"	"CCSToggleDimming()")
    list("Ctrl<Key>E"	"schHiReturn()")
    list("Ctrl<Key>F"	"hiGetCurrentWindow()->stopLevel = 0")
    ;list("Ctrl<Key>F11"	"deToggleToolbars()")

    list("Ctrl<Key>G"	"geHiDeleteMarker()")
    list("Ctrl<Key>M"	"(hiDisplayMenu LVSH_TopMenuNS)")
    list("Ctrl<Key>O"	"schHiGridOptions()")
    list("Ctrl<Key>P"	"schHiPlot()")
    list("Ctrl<Key>Q"	""	"geQuerySelSet()")
    list("Ctrl<Key>R"	""	"schSetEnv(\"upsideDown\" t)")
    list("Ctrl<Key>S"	"_schHiSaveAs()")
    ;list("Ctrl<Key>T"	"schHiZoomToSelSet()")
    list("Ctrl<Key>T"	"set_mypref()")
    list("Ctrl<Key>Tab"	"hiLowerWindow(hiGetCurrentWindow())")
    list("Ctrl<Key>V"	"hiFocusToCIW(hiGetCurrentWindow())")
    list("Ctrl<Key>W"	"hiCloseWindow(getCurrentWindow())")
    list("Ctrl<Key>Z"	"hiZoomRelativeScale(hiGetCurrentWindow() 2.0)")
    list("None<Btn1Down>"	"schSingleSelectPt()"	"mouseAddPt(t)")
    list("None<Btn1Down>(2)"	"schExtendSelectPt()"	"schMouseApplyOrFinish()")
    list("None<Btn2Down>"	"hiCloseWindow(hiGetCurrentWindow())"	"schHiMousePopUp()")
    list("None<Btn3Down>"	"schHiMousePopUp()"	"schCmdOption()")
    list("None<Btn3Down>(2)"	""	"hiToggleEnterForm()")
    list("None<Btn4Down>"	"geScroll(nil \"n\" nil)")
    list("None<Btn5Down>"	"geScroll(nil \"s\" nil)")
    list("Shift<Btn1Down>"	"schAddSelectPt()"	"mouseAddSelectPt()")
    list("Shift<Btn1Down>(2)"	"schExtendSelectPt()")
    list("Shift<Btn2Down>"	""	"schShiftCmdOption()")
    list("Shift<Btn3Down>"	""	"schShiftCmdOption()")
    list("Shift<Btn4Down>"	"geScroll(nil \"w\" nil)")
    list("Shift<Btn5Down>"	"geScroll(nil \"e\" nil)")
    list("Shift<DrawThru1>"	"schDirectEdit(2)"	"geAddSelectBox()")
    list("Shift<DrawThru3>"	"hiZoomOut()"	"hiZoomOut()")
    list("Shift<Key>1"	"load(\"~/myskill.il\")")
    list("Shift<Key>2"	"deInstallApp(getCurrentWindow() \"Schematics XL\")")
    list("Shift<Key>4"	"hiDeiconifyWindow(hiGetCIWindow()) hiRaiseWindow(hiGetCIWindow())")
    list("Shift<Key>5"	"displayMode(\"strip\")")
    list("Shift<Key>6"	"schHiOpenCellView()")
    ;list("Shift<Key>7"	"customizeNewSimCellView()")
    list("Shift<Key>7"	"createSimView()")
    list("Shift<Key>8"	"schHiHiliteLabel(\"instance\" \"off\")")
    list("Shift<Key>;"	"hiGetCurrentWindow()->drawGridOn=t 				hiGetCurrentWindow()->drawDottedGridOn=t ")
    list("Shift<Key>A"	"geSingleSelectBox()")
    list("Shift<Key>C"	"sevOpenCalculator()")
    list("Shift<Key>D"	"geSubSelectBox()")
    list("Shift<Key>E"	"schHiDescendEdit()")
    list("Shift<Key>F"	"hiGetCurrentWindow()->stopLevel = 20")
    list("Shift<Key>K"	"updatePinsFromSymbol(dgcv())")
    list("Shift<Key>F11"	"deToggleAssistants() deToggleToolbars()")
    list("Shift<Key>F10"	"schHiCheckAndSave() TIspiceNetlistAndRun(sevSession(hiGetCurrentWindow()))")
    list("Shift<Key>F12"	"sevNetlistFile(sevSession(getCurrentWindow() 'recreate)) sevNetlistAndRun(sevSession(getCurrentWindow()))")
    list("Shift<Key>F4"	"geToggleAreaSelectOption()")
    list("Shift<key>F6"	"XLCloseDataOpenData()")
    list("Shift<Key>G"	"descend_toggle()")
    list("<Key>h" "schHiEditInPlace()")
    ;list("Shift<Key>H"	"schHiHiliteLabel(\"wire\" \"off\")")
    list("Shift<Key>L"	"schHiCreateNoteLabel()")
    list("Shift<Key>M"	"schHiMove()")
    list("Shift<Key>N"	"schHiCreateNoteLabel()")
    list("Shift<Key>O"	"schHiEditorOptions()")
    list("Shift<Key>Q"	"schHiCellViewProperty()"	"schHiCellViewProperty()")
 ;  list("Shift<Key>R"	""	"schSetEnv(\"sideways\" t)")
    list("Shift<Key>R"	"awvRedisplayWindow(awvGetCurrentWindow())")
    list("Shift<Key>S"	"hiLowerWindow(hiGetCurrentWindow())")
;   list("Shift<Key>S"	"_schHiSave()")
    list("Shift<Key>T"	"schHiTree()")
    list("Shift<Key>U"	"hiRedo()")
    list("Shift<Key>V"	"_deToggleAssistant(\"World View\")")
    list("Shift<Key>W"	"schHiCreateWire(schGetEnv(\"defWideWireWidth\"))")
    list("Shift<Key>X"	"schHiCheckAndSave()")
    list("Shift<Key>Z"	"hiZoomRelativeScale(hiGetCurrentWindow() 0.5)")
    list("Alt Shift<Key>S"	"staticParasiticAnalysis()")
    list("Alt Shift<Key>B"	"addBoth()")
    list("Alt Shift<Key>D"	"addAVDD()")
    list("Alt Shift<Key>V"	"addAVSS()")
    list("Alt Shift<Key>F10"	"TIspiceViewNetlistDirFile(sevSession(hiGetCurrentWindow()) \"TISPICE_OUT\")" "hiRegTimer(\"hiScrollWindowBottom(hiGetCurrentWindow())\" 2)")
)) ;; hiSetBindKeys
;;-----------------------------------------------------------------------------

;;-----------------------------------------------------------------------------
;; Bindkeys for 'Command Interpreter'
;;-----------------------------------------------------------------------------
hiSetBindKeys( "Command Interpreter" list(
    list("<Key>F2"	"ddsOpenLibManager()")
    list("<Key>F4"	"setLibName()")
    list("<Key>F5"	"sevOpenCalculator()")
    list("<Key>F6"	"openForm()")
    list("<Key>F7"	"schHiNewCellView()"		"setLibName()")
    list("<Key>F1"	"hiHelp('window 'ciw window(1))")
    list("<Key>F3"	"hiToggleEnterForm()")
    list("<Key>F10"	"setTID()")
    list("<Key>F11"	"setTI4()")
    list("<Key>F12"	"setams()")
    list("Ctrl<Key>W"	"hiCloseWindow(hiGetCurrentWindow())")
    list("<Key>Help"	"hiHelp('window 'ciw window(1))")
    list("None<Btn2Down>"	"awvCloseWindow(awvGetCurrentWindow())")
)) ;; hiSetBindKeys
;;-----------------------------------------------------------------------------
;;-----------------------------------------------------------------------------
;; Bindkeys for 'adexl'
;;-----------------------------------------------------------------------------
hiSetBindKeys( "adexl" list(
    list("<Key>F11"	"deToggleAssistants()")
    list("Ctrl<Key>F11"	"deToggleToolbars()")
    list("Shift<Key>F11"	"deToggleAssistants() deToggleToolbars()")
    list("Shift<Key>C"	"sevOpenCalculator")
)) ;; hiSetBindKeys
;;-----------------------------------------------------------------------------

hiSetBindKeys( "ADE State" list(
    list("<Key>F11"	"deToggleAssistants()")
    list("Ctrl<Key>F11"	"deToggleToolbars()")
    list("Shift<Key>F11"	"deToggleAssistants() deToggleToolbars()")
    list("Shift<Key>C"	"sevOpenCalculator")
)) ;; hiSetBindKeys
;;-----------------------------------------------------------------------------

hiSetBindKeys( "awv" list(
    list("Ctrl<Key>R"	"awvRedisplayWindow(awvGetCurrentWindow())")
    list("Ctrl<Key>W"	"hiCloseWindow(awvGetCurrentWindow())")
    list("Shift<Key>5"	"displayMode(\"strip\")")
   list("Shift<Key>6"	"displayMode(\"composite\")")
     list("Ctrl Shift<Key>K"	"sevOpenCalculator()")
)) ;; hiSetBindKeys
;;-----------------------------------------------------------------------------

;;-----------------------------------------------------------------------------
;; Bindkeys for 'vivaGraph'
;;-----------------------------------------------------------------------------
hiSetBindKeys( "vivaGraph" list(
    list("Shift<Key>5"	"displayMode(\"strip\")")
    list("Shift<Key>6"	"displayMode(\"composite\")")
     list("Ctrl Shift<Key>K"	"sevOpenCalculator()")
     list("Ctrl Shift<Key>S"	"_ddtExecuteAction(awvGetCurrentWindow()->vivaSession \"graphSaveImage\")")
     list("Shift<Key>1"	"load(\"schBindKeys.il\")")
     list("Ctrl<Key>P"	"_ddtExecuteAction(awvGetCurrentWindow()->vivaSession \"graphPrint\")")
     list("Ctrl<Key>W"	"awvCloseWindow(awvGetCurrentWindow())")
     list("Ctrl<Key>Y"	"_ddtExecuteAction(awvGetCurrentWindow()->vivaSession \"fitYVisible\")")
    list("None<Btn2Down>"	"awvCloseWindow(awvGetCurrentWindow())")

))
;;-----------------------------------------------------------------------------
;; Bindkeys for 'symbol'
;;-----------------------------------------------------------------------------
hiSetBindKeys( "Symbol" list(
    list("Alt Shift<Key>C"	"schHiViewToView()")
    list("<Key>3"	"ddsOpenLibManager()")
    list("<Key>F5"	"hiRaiseWindow(if(sevSession(hiGetCurrentWindow()) sevSession(hiGetCurrentWindow())->window  hiGetCIWindow()))")
    list("<Key>6"	"customizeOpen()")
    list("<Key>7"	"customizeNew()")
    list("shift<Key>7"	"schHiNewCellView()")
    list("shift<Key>K"	"fromVAMSToSymbol")
    list("Ctrl Shift<Key>A"	"_schHiChangeEditMode(\"a\")")
    list("Ctrl Shift<Key>B"	"_schHiChangeEditMode(\"a\")")
    list("Ctrl Shift<Key>X"	"SosEditorMenuCB(\"SosCancelCheckOutItem\")")
    list("Ctrl Shift<Key>S"	"SosEditorMenuCB(\"SosCheckInItem\")")
    list("Ctrl Shift<Key>D"	"SosEditorMenuCB(\"SosCheckOutItem\")")
    list("Ctrl Shift<Key>E"	"schHiReturnToTop()")
    list("Ctrl Shift<Key>I"	"sevAnnotateResults(sevSession(getCurrentWindow()) 'dcOpPoints)")
    list("Ctrl Shift<Key>L"	"tiPdkPreviewPCellLayout()")
    list("Ctrl Shift<Key>N"	"sevAnnotateResults(sevSession(getCurrentWindow()) 'dcNodeVoltages)")
    list("Ctrl Shift<Key>O"    "toggleSnapSpacing()")
    list("Ctrl Shift<Key>P"	"changeSymbolInstPrefix()")
    list("Ctrl Shift<Key>Q"	"dssOpenVersionMCB()"	"hiiSetCurrentForm('dssOpenVersionForm)")
    list("Ctrl Shift<Key>R"	"_schHiChangeEditMode(\"r\")")
    list("Ctrl Shift<Key>V"	"SosEditorMenuCB(\"SosHistoryItem\")")
     list("Ctrl Shift<Key>Z"	"hiNextWinView(hiGetCurrentWindow())")
     list("Shift<Key>5"	"displayMode(\"strip\")")
    list("Shift<Key>6"	"displayMode(\"composite\")")
    list("Shift<Key>X"	"schHiVICAndSave()")
    ; list("Ctrl Shift<Key>C"	"sevOpenCalculator()")
     list("Shift<Key>1"	"load(\"schBindKeys.il\")")
    list("Ctrl<Key>W"	"hiCloseWindow(getCurrentWindow())")
    list("Ctrl<Key>E"	"_deUp()")
))
;;-----------------------------------------------------------------------------
;; Bindkeys for 'Verilog-AMS'
;;-----------------------------------------------------------------------------

hiSetBindKeys( "Verilog-AMS" list(

;	Key			[;alternate encodings used for same key]
;				Normal Action
;				[Enter Function Action	;EF]
    list("<DrawThru1>"	"schDirectEdit(1)"	"geSingleSelectBox()")
    list("<DrawThru3>"	"hiZoomIn()"	"hiZoomIn()")
    list("<Key>#"	"hiToggleAnchorMagnifier()")
    list("<Key>'"	"hiUpdateMagOptions()")
    list("<Key>."	"hiToggleMagnifier()")
    list("<Key>2"	"deInstallApp(getCurrentWindow() \"analogArtist-Schematic\")")
    list("<Key>3"	"ddsOpenLibManager()")
    list("<Key>4"	"setLibName()")
    list("<Key>5"	"schHiRouteFlightLine()")
    list("<Key>6"	"customizeOpen()")
    list("<Key>7"	"schHiNewCellView()"		"setLibName()")
    list("<Key>8"	"schHiHiliteLabel(\"instance\" \"on\")")
    list("<Key>9"	"geAddNetProbe()")
    list("<Key>0"	"geEnterDeleteNetProbe()")
    list("<Key>1"	"geDeleteAllProbe(getCurrentWindow() t)")
;    list("<Key>="	"hiGetCurrentWindow()->drawGridOn=t 				hiGetCurrentWindow()->drawDottedGridOn=nil ")
    list("<Key>-"	"hiZoomRelativeScale(getCurrentWindow() 0.5)")
    list("<Key>="	"hiZoomRelativeScale(getCurrentWindow() 2)")
    list("<Key>A"	"geSingleSelectPoint()")
    ;list("<Key>B"	"schHiCreateBlockInst()")
    list("<Key>B"	"change_name()")
    list("<Key>BackSpace"	"schHiDelete()"	"deletePoint()")
    list("<Key>C"	"schHiCopy()")
;    list("<Key>D"	"geSubSelectPoint()")
     list("<Key>S"	"geSubSelectPoint()")
    list("<Key>D"	"schHiDelete()")
   list("<Key>Delete"	"schHiDelete()")
    list("<Key>Down"	"geScroll(nil \"s\" nil)")
    list("<Key>E"	"schHiDescendRead()")
    list("<Key>Escape"	""	"cancelEnterFun()")
    list("<Key>F"	"hiZoomAbsoluteScale(getCurrentWindow() 0.9)")
    list("<Key>F1"	"hiHelp('window deGetAppInfo(deGetEditViewType(hiGetCurrentWindow()))->appName)")
    list("<Key>F10"	"setTID()")
    list("<Key>F11"	"setTI4()")
    list("<Key>F12"	"setams()")
;    list("<Key>F11"	"deToggleAssistants()")
    list("<Key>F2"	"schHiSaveCellView()")
    list("<Key>F3"	""	"hiToggleEnterForm()")
    list("<Key>F4"	"geTogglePartialSelect()")
    list("<Key>F6"	"hiRedraw()")
    list("<Key>G"	"curr_win_toggle()")
    list("<Key>h" "schHiEditInPlace()")
    ;list("<Key>H"	"schHiHiliteLabel(\"wire\" \"on\")")
    list("<Key>I"	"customizeInsert()")
    list("<Key>L"	"schHiCreateWireLabel()")
    list("<Key>Left"	"geScroll(nil \"w\" nil)")
    list("<Key>M"	"schHiStretch()")
    list("<Key>N"	"schHiCreateNoteShape()")
    list("<Key>O"	"schHiDisplayOptions()")
    list("<Key>P"	"schHiCreatePin()")
    list("<Key>Q"	"schHiObjectProperty()"	"schHiObjectProperty()")
    list("<Key>R"	"schHiRotate()"	"schSetEnv(\"rotate\" t)")
    list("<Key>Return"	"hiPrevWinView(hiGetCurrentWindow())")
    list("<Key>Right"	"geScroll(nil \"e\" nil)")
    list("<Key>S"	""	"schSnapToConn()")
    list("<Key>T"	"leHiLayerTap()")
    list("<Key>Tab"	"hiPan()")
    list("<Key>U"	"hiUndo()")
    list("<Key>Up"	"geScroll(nil \"n\" nil)")
    list("<Key>V"	"hiVectorPan()")
    list("<Key>W"	"schHiCreateWire(0.0)")
    list("<Key>X"	"schHiCheck(\"run\")")
    list("<Key>Y"	"UCRelMove()")
    list("<Key>Z"	"hiZoomIn()")
    list("<Key>["	"hiZoomRelativeScale(getCurrentWindow() 0.8)")
    list("<Key>]"	"hiZoomRelativeScale(getCurrentWindow() 1.25)")
    list("<Key>space"	"schHiCreateWireStubs()")
    list("Ctrl Shift<Btn1Down>"	"hiZoomInMagnifier(hiGetCurrentWindow())")
    list("Ctrl Shift<Btn2Down>"	"hiZoomOutMagnifier(hiGetCurrentWindow())")
    list("Ctrl Shift<Btn4Down>"	"hiScaleMagnifier(1.25)")
    list("Ctrl Shift<Btn5Down>"	"hiScaleMagnifier(0.80)")
    list("Ctrl Shift<Key>Down"	"hiScaleMagnifier(0.80)")
    list("Ctrl Shift<Key>Up"	"hiScaleMagnifier(1.25)")
    list("Ctrl Shift<Key>A"	"_schHiChangeEditMode(\"a\")")
    list("Ctrl Shift<Key>X"	"SosEditorMenuCB(\"SosCancelCheckOutItem\")")
    list("Ctrl Shift<Key>S"	"SosEditorMenuCB(\"SosCheckInItem\")")
    list("Ctrl Shift<Key>D"	"SosEditorMenuCB(\"SosCheckOutItem\")")
    list("Ctrl Shift<Key>E"	"schHiReturnToTop()")
    list("Ctrl Shift<Key>I"	"sevAnnotateResults(sevSession(getCurrentWindow()) 'dcOpPoints)")
    list("Ctrl Shift<Key>L"	"tiPdkPreviewPCellLayout()")
    list("Ctrl Shift<Key>N"	"sevAnnotateResults(sevSession(getCurrentWindow()) 'dcNodeVoltages)")
     list("Ctrl Shift<Key>P"	"sevAnnotateResults(sevSession(getCurrentWindow()) 'componentParameters)")
     list("Ctrl Shift<Key>Q"	"dssOpenVersionMCB()"	"hiiSetCurrentForm('dssOpenVersionForm)")
    list("Ctrl Shift<Key>V"	"SosEditorMenuCB(\"SosHistoryItem\")")
    list("Ctrl Shift<Key>R"	"_schHiChangeEditMode(\"r\")")
     list("Ctrl Shift<Key>Z"	"hiNextWinView(hiGetCurrentWindow())")
   list("Ctrl<Btn1Down>"	"mouseSubSelectPt()"	"mouseSubSelectPt()")
    list("Ctrl<Btn4Down>"	"hiZoomInAtMouse()")
    list("Ctrl<Btn5Down>"	"hiZoomOutAtMouse()")
    list("Ctrl<DrawThru1>"	"schDirectEdit(3)"	"geSubSelectBox()")
    list("Ctrl<Key>A"	"geSelectAllFig()")
    ;list("Ctrl<Key>D"	"geDeselectAllFig()")
    list("Ctrl<Key>D"	"CCSToggleDimming()")
    list("Ctrl<Key>E"	"schHDLReturn()")
    list("Ctrl<Key>F"	"hiDisplayForm(hiSearchForm)"	"hiiSetCurrentForm('hiSearchForm)")
    list("Ctrl<Key>F11"	"deToggleToolbars()")
    list("Ctrl<Key>G"	"geHiDeleteMarker()")
    list("Ctrl<Key>M"	"(hiDisplayMenu LVSH_TopMenuNS)")
    list("Ctrl<Key>O"	"deOpen(nil getCurrentWindow())" "hiiSetCurrentForm('deOpenForm)")
    list("Ctrl<Key>Q"	""	"geQuerySelSet()")
    list("Ctrl<Key>R"	""	"schSetEnv(\"upsideDown\" t)")
    list("Ctrl<Key>S"	"hiSaveAsViewfile()")
    ;list("Ctrl<Key>T"	"schHiZoomToSelSet()")
    list("Ctrl<Key>T"	"set_mypref()")
    list("Ctrl<Key>Tab"	"hiLowerWindow(hiGetCurrentWindow())")
    list("Ctrl<Key>V"	"hiFocusToCIW(hiGetCurrentWindow())")
    list("Ctrl<Key>W"	"hiCloseWindow(getCurrentWindow())")
    list("Ctrl<Key>Z"	"hiZoomRelativeScale(hiGetCurrentWindow() 2.0)")
    list("None<Btn1Down>"	"schSingleSelectPt()"	"mouseAddPt(t)")
    list("None<Btn1Down>(2)"	"schExtendSelectPt()"	"schMouseApplyOrFinish()")
    list("None<Btn2Down>"	"hiCloseWindow(hiGetCurrentWindow())"	"schHiMousePopUp()")
    list("None<Btn3Down>"	"schHiMousePopUp()"	"schCmdOption()")
    list("None<Btn3Down>(2)"	""	"hiToggleEnterForm()")
    list("None<Btn4Down>"	"geScroll(nil \"n\" nil)")
    list("None<Btn5Down>"	"geScroll(nil \"s\" nil)")
    list("Shift<Btn1Down>"	"schAddSelectPt()"	"mouseAddSelectPt()")
    list("Shift<Btn1Down>(2)"	"schExtendSelectPt()")
    list("Shift<Btn2Down>"	""	"schShiftCmdOption()")
    list("Shift<Btn3Down>"	""	"schShiftCmdOption()")
    list("Shift<Btn4Down>"	"geScroll(nil \"w\" nil)")
    list("Shift<Btn5Down>"	"geScroll(nil \"e\" nil)")
    list("Shift<DrawThru1>"	"schDirectEdit(2)"	"geAddSelectBox()")
    list("Shift<DrawThru3>"	"hiZoomOut()"	"hiZoomOut()")
    list("Shift<Key>1"	"load(\"~/myskill.il\")")
    list("Shift<Key>2"	"deInstallApp(getCurrentWindow() \"Schematics XL\")")
    list("Shift<Key>4"	"hiDeiconifyWindow(hiGetCIWindow()) hiRaiseWindow(hiGetCIWindow())")
    list("Shift<Key>5"	"displayMode(\"strip\")")
    list("Shift<Key>6"	"displayMode(\"composite\")")
    list("Shift<Key>7"	"timspseZoomSel()")
    list("Shift<Key>8"	"schHiHiliteLabel(\"instance\" \"off\")")
    list("Shift<Key>;"	"hiGetCurrentWindow()->drawGridOn=t 				hiGetCurrentWindow()->drawDottedGridOn=t ")
    list("Shift<Key>A"	"geSingleSelectBox()")
     list("Shift<Key>C"	"sevOpenCalculator()")
    list("Shift<Key>D"	"geSubSelectBox()")
    list("Shift<Key>E"	"schHiDescendEdit()")
    list("Shift<Key>F"	"hiGetCurrentWindow()->stopLevel = 20")
    list("Shift<Key>F11"	"deToggleAssistants() deToggleToolbars()")
    list("Shift<key>F10"	"TIspiceNetlistAndRun(sevSession(getCurrentWindow()))")
    list("Shift<Key>F4"	"geToggleAreaSelectOption()")
    list("Shift<key>F6"	"XLCloseDataOpenData()")
    list("Shift<Key>G"	"descend_toggle()")
    list("<Key>h" "schHiEditInPlace()")
    ;list("Shift<Key>H"	"schHiHiliteLabel(\"wire\" \"off\")")
    list("Shift<Key>L"	"schHiCreateNoteLabel()")
    list("Shift<Key>M"	"schHiMove()")
    list("Shift<Key>N"	"schHiCreateNoteLabel()")
    list("Shift<Key>O"	"schHiEditorOptions()")
    list("Shift<Key>Q"	"schHiCellViewProperty()"	"schHiCellViewProperty()")
 ;   list("Shift<Key>R"	""	"schSetEnv(\"sideways\" t)")
   list("Shift<Key>R"	"awvRedisplayWindow(awvGetCurrentWindow())")
;    list("Shift<Key>S"	"_schHiSave()")
    list("Shift<Key>S"	"hiLowerWindow(hiGetCurrentWindow())")
    list("Shift<Key>T"	"schHiTree()")
    list("Shift<Key>U"	"hiRedo()")
    list("Shift<Key>V"	"_deToggleAssistant(\"World View\")")
    list("Shift<Key>W"	"schHiCreateWire(schGetEnv(\"defWideWireWidth\"))")
    list("Shift<Key>X"	"schHiCheckAndSave()")
    list("Shift<Key>Z"	"hiZoomRelativeScale(hiGetCurrentWindow() 0.5)")

))

hiSetBindKeys( "Read veriloga" list(

;	Key			[;alternate encodings used for same key]
;				Normal Action
;				[Enter Function Action	;EF]
    list("<DrawThru1>"	"schDirectEdit(1)"	"geSingleSelectBox()")
    list("<DrawThru3>"	"hiZoomIn()"	"hiZoomIn()")
    list("<Key>#"	"hiToggleAnchorMagnifier()")
    list("<Key>'"	"hiUpdateMagOptions()")
    list("<Key>."	"hiToggleMagnifier()")
    list("<Key>2"	"deInstallApp(getCurrentWindow() \"analogArtist-Schematic\")")
    list("<Key>3"	"ddsOpenLibManager()")
    list("<Key>4"	"setLibName()")
    list("<Key>5"	"schHiRouteFlightLine()")
    list("<Key>6"	"customizeOpen()")
    list("<Key>7"	"schHiNewCellView()"		"setLibName()")
    list("<Key>8"	"schHiHiliteLabel(\"instance\" \"on\")")
    list("<Key>9"	"geAddNetProbe()")
    list("<Key>0"	"geEnterDeleteNetProbe()")
    list("<Key>1"	"geDeleteAllProbe(getCurrentWindow() t)")
;    list("<Key>="	"hiGetCurrentWindow()->drawGridOn=t 				hiGetCurrentWindow()->drawDottedGridOn=nil ")
    list("<Key>-"	"hiZoomRelativeScale(getCurrentWindow() 0.5)")
    list("<Key>="	"hiZoomRelativeScale(getCurrentWindow() 2)")
    list("<Key>A"	"geSingleSelectPoint()")
    ;list("<Key>B"	"schHiCreateBlockInst()")
    list("<Key>B"	"change_name()")
    list("<Key>BackSpace"	"schHiDelete()"	"deletePoint()")
    list("<Key>C"	"schHiCopy()")
;    list("<Key>D"	"geSubSelectPoint()")
     list("<Key>S"	"geSubSelectPoint()")
    list("<Key>D"	"schHiDelete()")
   list("<Key>Delete"	"schHiDelete()")
    list("<Key>Down"	"geScroll(nil \"s\" nil)")
    list("<Key>E"	"schHiDescendRead()")
    list("<Key>Escape"	""	"cancelEnterFun()")
    list("<Key>F"	"hiZoomAbsoluteScale(getCurrentWindow() 0.9)")
    list("<Key>F1"	"hiHelp('window deGetAppInfo(deGetEditViewType(hiGetCurrentWindow()))->appName)")
    list("<Key>F10"	"setTID()")
    list("<Key>F11"	"setTI4()")
    list("<Key>F12"	"setams()")
;    list("<Key>F11"	"deToggleAssistants()")
    list("<Key>F2"	"schHiSaveCellView()")
    list("<Key>F3"	""	"hiToggleEnterForm()")
    list("<Key>F4"	"geTogglePartialSelect()")
    list("<Key>F6"	"hiRedraw()")
    list("<Key>G"	"curr_win_toggle()")
    list("<Key>h" "schHiEditInPlace()")
    ;list("<Key>H"	"schHiHiliteLabel(\"wire\" \"on\")")
    list("<Key>I"	"customizeInsert()")
    list("<Key>L"	"schHiCreateWireLabel()")
    list("<Key>Left"	"geScroll(nil \"w\" nil)")
    list("<Key>M"	"schHiStretch()")
    list("<Key>N"	"schHiCreateNoteShape()")
    list("<Key>O"	"schHiDisplayOptions()")
    list("<Key>P"	"schHiCreatePin()")
    list("<Key>Q"	"schHiObjectProperty()"	"schHiObjectProperty()")
    list("<Key>R"	"schHiRotate()"	"schSetEnv(\"rotate\" t)")
    list("<Key>Return"	"hiPrevWinView(hiGetCurrentWindow())")
    list("<Key>Right"	"geScroll(nil \"e\" nil)")
    list("<Key>S"	""	"schSnapToConn()")
    list("<Key>T"	"leHiLayerTap()")
    list("<Key>Tab"	"hiPan()")
    list("<Key>U"	"hiUndo()")
    list("<Key>Up"	"geScroll(nil \"n\" nil)")
    list("<Key>V"	"hiVectorPan()")
    list("<Key>W"	"schHiCreateWire(0.0)")
    list("<Key>X"	"schHiCheck(\"run\")")
    list("<Key>Y"	"UCRelMove()")
    list("<Key>Z"	"hiZoomIn()")
    list("<Key>["	"hiZoomRelativeScale(getCurrentWindow() 0.8)")
    list("<Key>]"	"hiZoomRelativeScale(getCurrentWindow() 1.25)")
    list("<Key>space"	"schHiCreateWireStubs()")
    list("Ctrl Shift<Btn1Down>"	"hiZoomInMagnifier(hiGetCurrentWindow())")
    list("Ctrl Shift<Btn2Down>"	"hiZoomOutMagnifier(hiGetCurrentWindow())")
    list("Ctrl Shift<Btn4Down>"	"hiScaleMagnifier(1.25)")
    list("Ctrl Shift<Btn5Down>"	"hiScaleMagnifier(0.80)")
    list("Ctrl Shift<Key>Down"	"hiScaleMagnifier(0.80)")
    list("Ctrl Shift<Key>Up"	"hiScaleMagnifier(1.25)")
    list("Ctrl Shift<Key>A"	"_schHiChangeEditMode(\"a\")")
    list("Ctrl Shift<Key>X"	"SosEditorMenuCB(\"SosCancelCheckOutItem\")")
    list("Ctrl Shift<Key>S"	"SosEditorMenuCB(\"SosCheckInItem\")")
    list("Ctrl Shift<Key>D"	"SosEditorMenuCB(\"SosCheckOutItem\")")
    list("Ctrl Shift<Key>E"	"schHiReturnToTop()")
    list("Ctrl Shift<Key>I"	"sevAnnotateResults(sevSession(getCurrentWindow()) 'dcOpPoints)")
    list("Ctrl Shift<Key>L"	"tiPdkPreviewPCellLayout()")
    list("Ctrl Shift<Key>N"	"sevAnnotateResults(sevSession(getCurrentWindow()) 'dcNodeVoltages)")
     list("Ctrl Shift<Key>P"	"sevAnnotateResults(sevSession(getCurrentWindow()) 'componentParameters)")
     list("Ctrl Shift<Key>Q"	"dssOpenVersionMCB()"	"hiiSetCurrentForm('dssOpenVersionForm)")
    list("Ctrl Shift<Key>V"	"SosEditorMenuCB(\"SosHistoryItem\")")
    list("Ctrl Shift<Key>R"	"_schHiChangeEditMode(\"r\")")
     list("Ctrl Shift<Key>Z"	"hiNextWinView(hiGetCurrentWindow())")
   list("Ctrl<Btn1Down>"	"mouseSubSelectPt()"	"mouseSubSelectPt()")
    list("Ctrl<Btn4Down>"	"hiZoomInAtMouse()")
    list("Ctrl<Btn5Down>"	"hiZoomOutAtMouse()")
    list("Ctrl<DrawThru1>"	"schDirectEdit(3)"	"geSubSelectBox()")
    list("Ctrl<Key>A"	"geSelectAllFig()")
    ;list("Ctrl<Key>D"	"geDeselectAllFig()")
    list("Ctrl<Key>D"	"CCSToggleDimming()")
    list("Ctrl<Key>E"	"schHDLReturn()")
    list("Ctrl<Key>F"	"hiDisplayForm(hiSearchForm)"	"hiiSetCurrentForm('hiSearchForm)")
    list("Ctrl<Key>F11"	"deToggleToolbars()")
    list("Ctrl<Key>G"	"geHiDeleteMarker()")
    list("Ctrl<Key>M"	"(hiDisplayMenu LVSH_TopMenuNS)")
    list("Ctrl<Key>O"	"deOpen(nil getCurrentWindow())" "hiiSetCurrentForm('deOpenForm)")
;    list("Ctrl<Key>Q"	""	"geQuerySelSet()")
    list("Ctrl<Key>R"	""	"schSetEnv(\"upsideDown\" t)")
    list("Ctrl<Key>S"	"hiSaveAsViewfile()")
    ;list("Ctrl<Key>T"	"schHiZoomToSelSet()")
    list("Ctrl<Key>T"	"set_mypref()")
    list("Ctrl<Key>Tab"	"hiLowerWindow(hiGetCurrentWindow())")
    list("Ctrl<Key>V"	"hiFocusToCIW(hiGetCurrentWindow())")
    list("Ctrl<Key>W"	"hiCloseWindow(getCurrentWindow())")
     list("Ctrl<Key>Q"	"hiCloseWindow(getCurrentWindow())")
   list("Ctrl<Key>Z"	"hiZoomRelativeScale(hiGetCurrentWindow() 2.0)")
    list("None<Btn1Down>"	"schSingleSelectPt()"	"mouseAddPt(t)")
    list("None<Btn1Down>(2)"	"schExtendSelectPt()"	"schMouseApplyOrFinish()")
    list("None<Btn2Down>"	"schHiMousePopUp()"	"schHiMousePopUp()")
    list("None<Btn3Down>"	"schHiMousePopUp()"	"schCmdOption()")
    list("None<Btn3Down>(2)"	""	"hiToggleEnterForm()")
    list("None<Btn4Down>"	"geScroll(nil \"n\" nil)")
    list("None<Btn5Down>"	"geScroll(nil \"s\" nil)")
    list("Shift<Btn1Down>"	"schAddSelectPt()"	"mouseAddSelectPt()")
    list("Shift<Btn1Down>(2)"	"schExtendSelectPt()")
    list("Shift<Btn2Down>"	""	"schShiftCmdOption()")
    list("Shift<Btn3Down>"	""	"schShiftCmdOption()")
    list("Shift<Btn4Down>"	"geScroll(nil \"w\" nil)")
    list("Shift<Btn5Down>"	"geScroll(nil \"e\" nil)")
    list("Shift<DrawThru1>"	"schDirectEdit(2)"	"geAddSelectBox()")
    list("Shift<DrawThru3>"	"hiZoomOut()"	"hiZoomOut()")
    list("Shift<Key>1"	"load(\"~/myskill.il\")")
    list("Shift<Key>2"	"deInstallApp(getCurrentWindow() \"Schematics XL\")")
    list("Shift<Key>4"	"hiDeiconifyWindow(hiGetCIWindow()) hiRaiseWindow(hiGetCIWindow())")
    list("Shift<Key>5"	"displayMode(\"strip\")")
    list("Shift<Key>6"	"displayMode(\"composite\")")
    list("Shift<Key>7"	"timspseZoomSel()")
    list("Shift<Key>8"	"schHiHiliteLabel(\"instance\" \"off\")")
    list("Shift<Key>;"	"hiGetCurrentWindow()->drawGridOn=t 				hiGetCurrentWindow()->drawDottedGridOn=t ")
    list("Shift<Key>A"	"geSingleSelectBox()")
     list("Shift<Key>C"	"sevOpenCalculator()")
    list("Shift<Key>D"	"geSubSelectBox()")
    list("Shift<Key>E"	"schHiDescendEdit()")
    list("Shift<Key>F"	"hiGetCurrentWindow()->stopLevel = 20")
    list("Shift<Key>F11"	"deToggleAssistants() deToggleToolbars()")
    list("Shift<key>F10"	"TIspiceNetlistAndRun(sevSession(getCurrentWindow()))")
    list("Shift<Key>F4"	"geToggleAreaSelectOption()")
    list("Shift<key>F6"	"XLCloseDataOpenData()")
    list("Shift<Key>G"	"descend_toggle()")
    list("<Key>h" "schHiEditInPlace()")
    ;list("Shift<Key>H"	"schHiHiliteLabel(\"wire\" \"off\")")
    list("Shift<Key>L"	"schHiCreateNoteLabel()")
    list("Shift<Key>M"	"schHiMove()")
    list("Shift<Key>N"	"schHiCreateNoteLabel()")
    list("Shift<Key>O"	"schHiEditorOptions()")
    list("Shift<Key>Q"	"schHiCellViewProperty()"	"schHiCellViewProperty()")
 ;   list("Shift<Key>R"	""	"schSetEnv(\"sideways\" t)")
   list("Shift<Key>R"	"awvRedisplayWindow(awvGetCurrentWindow())")
    list("Shift<Key>S"	"_schHiSave()")
    list("Shift<Key>T"	"schHiTree()")
    list("Shift<Key>U"	"hiRedo()")
    list("Shift<Key>V"	"_deToggleAssistant(\"World View\")")
    list("Shift<Key>W"	"schHiCreateWire(schGetEnv(\"defWideWireWidth\"))")
    list("Shift<Key>X"	"schHiCheckAndSave()")
    list("Shift<Key>Z"	"hiZoomRelativeScale(hiGetCurrentWindow() 0.5)")

))

hiSetBindKeys( "Show File" list(

;	Key			[;alternate encodings used for same key]
;				Normal Action
;				[Enter Function Action	;EF]

list("<Key>6"		"customizeOpen()")
list("<Key>End"			"hiScrollWindowBottom(hiGetCurrentWindow())")
list("<Key>Next"		"hiScrollWindowDown(hiGetCurrentWindow())")
list("<Key>Space"		"hiScrollWindowDown(hiGetCurrentWindow())")
list("<Key>Prior"		"hiScrollWindowUp(hiGetCurrentWindow())")
list("<Key>F1"		"hiHelp('window \"Show File\" hiGetCurrentWindow())")
list("<Key>G"		"hiGetCurrentIndex(hiGetCurrentWindow())")
list("<Key>u"		"hiScrollWindowUp(hiGetCurrentWindow())")
list("<Key>d"		"hiScrollWindowDown(hiGetCurrentWindow())")
list("<Key>b"		"hiScrollWindowBottom(hiGetCurrentWindow())")
list("<Key>t"		"hiScrollWindowTop(hiGetCurrentWindow())")
list("Ctrl<Key>F"		"hiDisplayForm(hiSearchForm)")
list("Ctrl<Key>O"		"hiOpenNextFile()")
list("Ctrl<Key>U"		"hiEnableUpdateWindowCB()")
list("Ctrl<Key>P"		"hiDisableUpdateWindowCB()")
list("Ctrl<Key>G"		"hiGetCurrentIndex(hiGetCurrentWindow())")
list("Ctrl<Key>L"		"hiDisplayForm(hiGoToLineForm)")
list("Ctrl<Key>A"		"_hiSelectAll(hiGetCurrentWindow())")
list("Ctrl<Key>S"		"hiSaveAsViewfile()")
list("Ctrl<Key>b"		"hiScrollWindowUp(hiGetCurrentWindow())")
;list("Ctrl<Key>f"		"hiScrollWindowDown(hiGetCurrentWindow())")
list("Ctrl<Key>w"		"hiEditFileQuitTrigger(-1 0)")
list("Ctrl<Key>q"		"hiEditFileQuitTrigger(-1 0)")

list("Shift<Key>g"		"hiScrollWindowBottom(hiGetCurrentWindow())")
))

hiSetBindKeys( "Read HDL" list(

;	Key			[;alternate encodings used for same key]
;				Normal Action
;				[Enter Function Action	;EF]
    list("<DrawThru1>"	"schDirectEdit(1)"	"geSingleSelectBox()")
    list("<DrawThru3>"	"hiZoomIn()"	"hiZoomIn()")
    list("<Key>#"	"hiToggleAnchorMagnifier()")
    list("<Key>'"	"hiUpdateMagOptions()")
    list("<Key>."	"hiToggleMagnifier()")
    list("<Key>2"	"deInstallApp(getCurrentWindow() \"analogArtist-Schematic\")")
    list("<Key>3"	"ddsOpenLibManager()")
    list("<Key>4"	"setLibName()")
    list("<Key>5"	"schHiRouteFlightLine()")
    list("<Key>6"	"customizeOpen()")
    list("<Key>7"	"schHiNewCellView()"		"setLibName()")
    list("<Key>8"	"schHiHiliteLabel(\"instance\" \"on\")")
    list("<Key>9"	"geAddNetProbe()")
    list("<Key>0"	"geEnterDeleteNetProbe()")
    list("<Key>1"	"geDeleteAllProbe(getCurrentWindow() t)")
;    list("<Key>="	"hiGetCurrentWindow()->drawGridOn=t 				hiGetCurrentWindow()->drawDottedGridOn=nil ")
    list("<Key>-"	"hiZoomRelativeScale(getCurrentWindow() 0.5)")
    list("<Key>="	"hiZoomRelativeScale(getCurrentWindow() 2)")
    list("<Key>A"	"geSingleSelectPoint()")
    ;list("<Key>B"	"schHiCreateBlockInst()")
    list("<Key>B"	"change_name()")
    list("<Key>BackSpace"	"schHiDelete()"	"deletePoint()")
    list("<Key>C"	"schHiCopy()")
;    list("<Key>D"	"geSubSelectPoint()")
     list("<Key>S"	"geSubSelectPoint()")
    list("<Key>D"	"schHiDelete()")
   list("<Key>Delete"	"schHiDelete()")
    list("<Key>Down"	"geScroll(nil \"s\" nil)")
    list("<Key>E"	"schHiDescendRead()")
    list("<Key>Escape"	""	"cancelEnterFun()")
    list("<Key>F"	"hiZoomAbsoluteScale(getCurrentWindow() 0.9)")
    list("<Key>F1"	"hiHelp('window deGetAppInfo(deGetEditViewType(hiGetCurrentWindow()))->appName)")
    list("<Key>F10"	"setTID()")
    list("<Key>F11"	"setTI4()")
    list("<Key>F12"	"setams()")
;    list("<Key>F11"	"deToggleAssistants()")
    list("<Key>F2"	"schHiSaveCellView()")
    list("<Key>F3"	""	"hiToggleEnterForm()")
    list("<Key>F4"	"geTogglePartialSelect()")
    list("<Key>F6"	"hiRedraw()")
    list("<Key>G"	"curr_win_toggle()")
    list("<Key>h" "schHiEditInPlace()")
    ;list("<Key>H"	"schHiHiliteLabel(\"wire\" \"on\")")
    list("<Key>I"	"customizeInsert()")
    list("<Key>L"	"schHiCreateWireLabel()")
    list("<Key>Left"	"geScroll(nil \"w\" nil)")
    list("<Key>M"	"schHiStretch()")
    list("<Key>N"	"schHiCreateNoteShape()")
    list("<Key>O"	"schHiDisplayOptions()")
    list("<Key>P"	"schHiCreatePin()")
    list("<Key>Q"	"schHiObjectProperty()"	"schHiObjectProperty()")
    list("<Key>R"	"schHiRotate()"	"schSetEnv(\"rotate\" t)")
    list("<Key>Return"	"hiPrevWinView(hiGetCurrentWindow())")
    list("<Key>Right"	"geScroll(nil \"e\" nil)")
    list("<Key>S"	""	"schSnapToConn()")
    list("<Key>T"	"leHiLayerTap()")
    list("<Key>Tab"	"hiPan()")
    list("<Key>U"	"hiUndo()")
    list("<Key>Up"	"geScroll(nil \"n\" nil)")
    list("<Key>V"	"hiVectorPan()")
    list("<Key>W"	"schHiCreateWire(0.0)")
    list("<Key>X"	"schHiCheck(\"run\")")
    list("<Key>Y"	"UCRelMove()")
    list("<Key>Z"	"hiZoomIn()")
    list("<Key>["	"hiZoomRelativeScale(getCurrentWindow() 0.8)")
    list("<Key>]"	"hiZoomRelativeScale(getCurrentWindow() 1.25)")
    list("<Key>space"	"schHiCreateWireStubs()")
    list("Ctrl Shift<Btn1Down>"	"hiZoomInMagnifier(hiGetCurrentWindow())")
    list("Ctrl Shift<Btn2Down>"	"hiZoomOutMagnifier(hiGetCurrentWindow())")
    list("Ctrl Shift<Btn4Down>"	"hiScaleMagnifier(1.25)")
    list("Ctrl Shift<Btn5Down>"	"hiScaleMagnifier(0.80)")
    list("Ctrl Shift<Key>Down"	"hiScaleMagnifier(0.80)")
    list("Ctrl Shift<Key>Up"	"hiScaleMagnifier(1.25)")
    list("Ctrl Shift<Key>A"	"_schHiChangeEditMode(\"a\")")
    list("Ctrl Shift<Key>X"	"SosEditorMenuCB(\"SosCancelCheckOutItem\")")
    list("Ctrl Shift<Key>S"	"SosEditorMenuCB(\"SosCheckInItem\")")
    list("Ctrl Shift<Key>D"	"SosEditorMenuCB(\"SosCheckOutItem\")")
    list("Ctrl Shift<Key>E"	"schHiReturnToTop()")
    list("Ctrl Shift<Key>I"	"sevAnnotateResults(sevSession(getCurrentWindow()) 'dcOpPoints)")
    list("Ctrl Shift<Key>L"	"tiPdkPreviewPCellLayout()")
    list("Ctrl Shift<Key>N"	"sevAnnotateResults(sevSession(getCurrentWindow()) 'dcNodeVoltages)")
     list("Ctrl Shift<Key>P"	"sevAnnotateResults(sevSession(getCurrentWindow()) 'componentParameters)")
     list("Ctrl Shift<Key>Q"	"dssOpenVersionMCB()"	"hiiSetCurrentForm('dssOpenVersionForm)")
    list("Ctrl Shift<Key>V"	"SosEditorMenuCB(\"SosHistoryItem\")")
    list("Ctrl Shift<Key>R"	"_schHiChangeEditMode(\"r\")")
     list("Ctrl Shift<Key>Z"	"hiNextWinView(hiGetCurrentWindow())")
   list("Ctrl<Btn1Down>"	"mouseSubSelectPt()"	"mouseSubSelectPt()")
    list("Ctrl<Btn4Down>"	"hiZoomInAtMouse()")
    list("Ctrl<Btn5Down>"	"hiZoomOutAtMouse()")
    list("Ctrl<DrawThru1>"	"schDirectEdit(3)"	"geSubSelectBox()")
    list("Ctrl<Key>A"	"geSelectAllFig()")
    ;list("Ctrl<Key>D"	"geDeselectAllFig()")
    list("Ctrl<Key>D"	"CCSToggleDimming()")
    list("Ctrl<Key>E"	"schHDLReturn()")
    list("Ctrl<Key>F"	"hiDisplayForm(hiSearchForm)"	"hiiSetCurrentForm('hiSearchForm)")
    list("Ctrl<Key>F11"	"deToggleToolbars()")
    list("Ctrl<Key>G"	"geHiDeleteMarker()")
    list("Ctrl<Key>M"	"(hiDisplayMenu LVSH_TopMenuNS)")
    list("Ctrl<Key>O"	"deOpen(nil getCurrentWindow())" "hiiSetCurrentForm('deOpenForm)")
;    list("Ctrl<Key>Q"	""	"geQuerySelSet()")
    list("Ctrl<Key>R"	""	"schSetEnv(\"upsideDown\" t)")
    list("Ctrl<Key>S"	"hiSaveAsViewfile()")
    ;list("Ctrl<Key>T"	"schHiZoomToSelSet()")
    list("Ctrl<Key>T"	"set_mypref()")
    list("Ctrl<Key>Tab"	"hiLowerWindow(hiGetCurrentWindow())")
    list("Ctrl<Key>V"	"hiFocusToCIW(hiGetCurrentWindow())")
    list("Ctrl<Key>W"	"hiCloseWindow(getCurrentWindow())")
     list("Ctrl<Key>Q"	"hiCloseWindow(getCurrentWindow())")
   list("Ctrl<Key>Z"	"hiZoomRelativeScale(hiGetCurrentWindow() 2.0)")
    list("None<Btn1Down>"	"schSingleSelectPt()"	"mouseAddPt(t)")
    list("None<Btn1Down>(2)"	"schExtendSelectPt()"	"schMouseApplyOrFinish()")
    list("None<Btn2Down>"	"schHiMousePopUp()"	"schHiMousePopUp()")
    list("None<Btn3Down>"	"schHiMousePopUp()"	"schCmdOption()")
    list("None<Btn3Down>(2)"	""	"hiToggleEnterForm()")
    list("None<Btn4Down>"	"geScroll(nil \"n\" nil)")
    list("None<Btn5Down>"	"geScroll(nil \"s\" nil)")
    list("Shift<Btn1Down>"	"schAddSelectPt()"	"mouseAddSelectPt()")
    list("Shift<Btn1Down>(2)"	"schExtendSelectPt()")
    list("Shift<Btn2Down>"	""	"schShiftCmdOption()")
    list("Shift<Btn3Down>"	""	"schShiftCmdOption()")
    list("Shift<Btn4Down>"	"geScroll(nil \"w\" nil)")
    list("Shift<Btn5Down>"	"geScroll(nil \"e\" nil)")
    list("Shift<DrawThru1>"	"schDirectEdit(2)"	"geAddSelectBox()")
    list("Shift<DrawThru3>"	"hiZoomOut()"	"hiZoomOut()")
    list("Shift<Key>1"	"load(\"~/myskill.il\")")
    list("Shift<Key>2"	"deInstallApp(getCurrentWindow() \"Schematics XL\")")
    list("Shift<Key>4"	"hiDeiconifyWindow(hiGetCIWindow()) hiRaiseWindow(hiGetCIWindow())")
    list("Shift<Key>5"	"displayMode(\"strip\")")
    list("Shift<Key>6"	"displayMode(\"composite\")")
    list("Shift<Key>7"	"timspseZoomSel()")
    list("Shift<Key>8"	"schHiHiliteLabel(\"instance\" \"off\")")
    list("Shift<Key>;"	"hiGetCurrentWindow()->drawGridOn=t 				hiGetCurrentWindow()->drawDottedGridOn=t ")
    list("Shift<Key>A"	"geSingleSelectBox()")
     list("Shift<Key>C"	"sevOpenCalculator()")
    list("Shift<Key>D"	"geSubSelectBox()")
    list("Shift<Key>E"	"schHiDescendEdit()")
    list("Shift<Key>F"	"hiGetCurrentWindow()->stopLevel = 20")
    list("Shift<Key>F11"	"deToggleAssistants() deToggleToolbars()")
    list("Shift<key>F10"	"TIspiceNetlistAndRun(sevSession(getCurrentWindow()))")
    list("Shift<Key>F4"	"geToggleAreaSelectOption()")
    list("Shift<key>F6"	"XLCloseDataOpenData()")
    list("Shift<Key>G"	"descend_toggle()")
    list("<Key>h" "schHiEditInPlace()")
    ;list("Shift<Key>H"	"schHiHiliteLabel(\"wire\" \"off\")")
    list("Shift<Key>L"	"schHiCreateNoteLabel()")
    list("Shift<Key>M"	"schHiMove()")
    list("Shift<Key>N"	"schHiCreateNoteLabel()")
    list("Shift<Key>O"	"schHiEditorOptions()")
    list("Shift<Key>Q"	"schHiCellViewProperty()"	"schHiCellViewProperty()")
 ;   list("Shift<Key>R"	""	"schSetEnv(\"sideways\" t)")
   list("Shift<Key>R"	"awvRedisplayWindow(awvGetCurrentWindow())")
    list("Shift<Key>S"	"_schHiSave()")
    list("Shift<Key>T"	"schHiTree()")
    list("Shift<Key>U"	"hiRedo()")
    list("Shift<Key>V"	"_deToggleAssistant(\"World View\")")
    list("Shift<Key>W"	"schHiCreateWire(schGetEnv(\"defWideWireWidth\"))")
    list("Shift<Key>X"	"schHiCheckAndSave()")
    list("Shift<Key>Z"	"hiZoomRelativeScale(hiGetCurrentWindow() 0.5)")

))

hiSetBindKeys( "systemVerilog" list(

;	Key			[;alternate encodings used for same key]
;				Normal Action
;				[Enter Function Action	;EF]
    list("<DrawThru1>"	"schDirectEdit(1)"	"geSingleSelectBox()")
    list("<DrawThru3>"	"hiZoomIn()"	"hiZoomIn()")
    list("<Key>#"	"hiToggleAnchorMagnifier()")
    list("<Key>'"	"hiUpdateMagOptions()")
    list("<Key>."	"hiToggleMagnifier()")
    list("<Key>2"	"deInstallApp(getCurrentWindow() \"analogArtist-Schematic\")")
    list("<Key>3"	"ddsOpenLibManager()")
    list("<Key>4"	"setLibName()")
    list("<Key>5"	"schHiRouteFlightLine()")
    list("<Key>6"	"customizeOpen()")
    list("<Key>7"	"schHiNewCellView()"		"setLibName()")
    list("<Key>8"	"schHiHiliteLabel(\"instance\" \"on\")")
    list("<Key>9"	"geAddNetProbe()")
    list("<Key>0"	"geEnterDeleteNetProbe()")
    list("<Key>1"	"geDeleteAllProbe(getCurrentWindow() t)")
;    list("<Key>="	"hiGetCurrentWindow()->drawGridOn=t 				hiGetCurrentWindow()->drawDottedGridOn=nil ")
    list("<Key>-"	"hiZoomRelativeScale(getCurrentWindow() 0.5)")
    list("<Key>="	"hiZoomRelativeScale(getCurrentWindow() 2)")
    list("<Key>A"	"geSingleSelectPoint()")
    ;list("<Key>B"	"schHiCreateBlockInst()")
    list("<Key>B"	"change_name()")
    list("<Key>BackSpace"	"schHiDelete()"	"deletePoint()")
    list("<Key>C"	"schHiCopy()")
;    list("<Key>D"	"geSubSelectPoint()")
     list("<Key>S"	"geSubSelectPoint()")
    list("<Key>D"	"schHiDelete()")
   list("<Key>Delete"	"schHiDelete()")
    list("<Key>Down"	"geScroll(nil \"s\" nil)")
    list("<Key>E"	"schHiDescendRead()")
    list("<Key>Escape"	""	"cancelEnterFun()")
    list("<Key>F"	"hiZoomAbsoluteScale(getCurrentWindow() 0.9)")
    list("<Key>F1"	"hiHelp('window deGetAppInfo(deGetEditViewType(hiGetCurrentWindow()))->appName)")
    list("<Key>F10"	"setTID()")
    list("<Key>F11"	"setTI4()")
    list("<Key>F12"	"setams()")
;    list("<Key>F11"	"deToggleAssistants()")
    list("<Key>F2"	"schHiSaveCellView()")
    list("<Key>F3"	""	"hiToggleEnterForm()")
    list("<Key>F4"	"geTogglePartialSelect()")
    list("<Key>F6"	"hiRedraw()")
    list("<Key>G"	"curr_win_toggle()")
    list("<Key>h" "schHiEditInPlace()")
    ;list("<Key>H"	"schHiHiliteLabel(\"wire\" \"on\")")
    list("<Key>I"	"customizeInsert()")
    list("<Key>L"	"schHiCreateWireLabel()")
    list("<Key>Left"	"geScroll(nil \"w\" nil)")
    list("<Key>M"	"schHiStretch()")
    list("<Key>N"	"schHiCreateNoteShape()")
    list("<Key>O"	"schHiDisplayOptions()")
    list("<Key>P"	"schHiCreatePin()")
    list("<Key>Q"	"schHiObjectProperty()"	"schHiObjectProperty()")
    list("<Key>R"	"schHiRotate()"	"schSetEnv(\"rotate\" t)")
    list("<Key>Return"	"hiPrevWinView(hiGetCurrentWindow())")
    list("<Key>Right"	"geScroll(nil \"e\" nil)")
    list("<Key>S"	""	"schSnapToConn()")
    list("<Key>T"	"leHiLayerTap()")
    list("<Key>Tab"	"hiPan()")
    list("<Key>U"	"hiUndo()")
    list("<Key>Up"	"geScroll(nil \"n\" nil)")
    list("<Key>V"	"hiVectorPan()")
    list("<Key>W"	"schHiCreateWire(0.0)")
    list("<Key>X"	"schHiCheck(\"run\")")
    list("<Key>Y"	"UCRelMove()")
    list("<Key>Z"	"hiZoomIn()")
    list("<Key>["	"hiZoomRelativeScale(getCurrentWindow() 0.8)")
    list("<Key>]"	"hiZoomRelativeScale(getCurrentWindow() 1.25)")
    list("<Key>space"	"schHiCreateWireStubs()")
    list("Ctrl Shift<Btn1Down>"	"hiZoomInMagnifier(hiGetCurrentWindow())")
    list("Ctrl Shift<Btn2Down>"	"hiZoomOutMagnifier(hiGetCurrentWindow())")
    list("Ctrl Shift<Btn4Down>"	"hiScaleMagnifier(1.25)")
    list("Ctrl Shift<Btn5Down>"	"hiScaleMagnifier(0.80)")
    list("Ctrl Shift<Key>Down"	"hiScaleMagnifier(0.80)")
    list("Ctrl Shift<Key>Up"	"hiScaleMagnifier(1.25)")
    list("Ctrl Shift<Key>A"	"_schHiChangeEditMode(\"a\")")
    list("Ctrl Shift<Key>X"	"SosEditorMenuCB(\"SosCancelCheckOutItem\")")
    list("Ctrl Shift<Key>S"	"SosEditorMenuCB(\"SosCheckInItem\")")
    list("Ctrl Shift<Key>D"	"SosEditorMenuCB(\"SosCheckOutItem\")")
    list("Ctrl Shift<Key>E"	"schHiReturnToTop()")
    list("Ctrl Shift<Key>I"	"sevAnnotateResults(sevSession(getCurrentWindow()) 'dcOpPoints)")
    list("Ctrl Shift<Key>L"	"tiPdkPreviewPCellLayout()")
    list("Ctrl Shift<Key>N"	"sevAnnotateResults(sevSession(getCurrentWindow()) 'dcNodeVoltages)")
     list("Ctrl Shift<Key>P"	"sevAnnotateResults(sevSession(getCurrentWindow()) 'componentParameters)")
     list("Ctrl Shift<Key>Q"	"dssOpenVersionMCB()"	"hiiSetCurrentForm('dssOpenVersionForm)")
    list("Ctrl Shift<Key>V"	"SosEditorMenuCB(\"SosHistoryItem\")")
    list("Ctrl Shift<Key>R"	"_schHiChangeEditMode(\"r\")")
     list("Ctrl Shift<Key>Z"	"hiNextWinView(hiGetCurrentWindow())")
   list("Ctrl<Btn1Down>"	"mouseSubSelectPt()"	"mouseSubSelectPt()")
    list("Ctrl<Btn4Down>"	"hiZoomInAtMouse()")
    list("Ctrl<Btn5Down>"	"hiZoomOutAtMouse()")
    list("Ctrl<DrawThru1>"	"schDirectEdit(3)"	"geSubSelectBox()")
    list("Ctrl<Key>A"	"geSelectAllFig()")
    ;list("Ctrl<Key>D"	"geDeselectAllFig()")
    list("Ctrl<Key>D"	"CCSToggleDimming()")
    list("Ctrl<Key>E"	"schHDLReturn()")
    list("Ctrl<Key>F"	"hiDisplayForm(hiSearchForm)"	"hiiSetCurrentForm('hiSearchForm)")
    list("Ctrl<Key>F11"	"deToggleToolbars()")
    list("Ctrl<Key>G"	"geHiDeleteMarker()")
    list("Ctrl<Key>M"	"(hiDisplayMenu LVSH_TopMenuNS)")
    list("Ctrl<Key>O"	"deOpen(nil getCurrentWindow())" "hiiSetCurrentForm('deOpenForm)")
;    list("Ctrl<Key>Q"	""	"geQuerySelSet()")
    list("Ctrl<Key>R"	""	"schSetEnv(\"upsideDown\" t)")
    list("Ctrl<Key>S"	"hiSaveAsViewfile()")
    ;list("Ctrl<Key>T"	"schHiZoomToSelSet()")
    list("Ctrl<Key>T"	"set_mypref()")
    list("Ctrl<Key>Tab"	"hiLowerWindow(hiGetCurrentWindow())")
    list("Ctrl<Key>V"	"hiFocusToCIW(hiGetCurrentWindow())")
    list("Ctrl<Key>W"	"hiCloseWindow(getCurrentWindow())")
     list("Ctrl<Key>Q"	"hiCloseWindow(getCurrentWindow())")
   list("Ctrl<Key>Z"	"hiZoomRelativeScale(hiGetCurrentWindow() 2.0)")
    list("None<Btn1Down>"	"schSingleSelectPt()"	"mouseAddPt(t)")
    list("None<Btn1Down>(2)"	"schExtendSelectPt()"	"schMouseApplyOrFinish()")
    list("None<Btn2Down>"	"schHiMousePopUp()"	"schHiMousePopUp()")
    list("None<Btn3Down>"	"schHiMousePopUp()"	"schCmdOption()")
    list("None<Btn3Down>(2)"	""	"hiToggleEnterForm()")
    list("None<Btn4Down>"	"geScroll(nil \"n\" nil)")
    list("None<Btn5Down>"	"geScroll(nil \"s\" nil)")
    list("Shift<Btn1Down>"	"schAddSelectPt()"	"mouseAddSelectPt()")
    list("Shift<Btn1Down>(2)"	"schExtendSelectPt()")
    list("Shift<Btn2Down>"	""	"schShiftCmdOption()")
    list("Shift<Btn3Down>"	""	"schShiftCmdOption()")
    list("Shift<Btn4Down>"	"geScroll(nil \"w\" nil)")
    list("Shift<Btn5Down>"	"geScroll(nil \"e\" nil)")
    list("Shift<DrawThru1>"	"schDirectEdit(2)"	"geAddSelectBox()")
    list("Shift<DrawThru3>"	"hiZoomOut()"	"hiZoomOut()")
    list("Shift<Key>1"	"load(\"schBindKeys.il\")")
    list("Shift<Key>2"	"deInstallApp(getCurrentWindow() \"Schematics XL\")")
    list("Shift<Key>4"	"hiDeiconifyWindow(hiGetCIWindow()) hiRaiseWindow(hiGetCIWindow())")
    list("Shift<Key>5"	"displayMode(\"strip\")")
    list("Shift<Key>6"	"displayMode(\"composite\")")
    list("Shift<Key>7"	"timspseZoomSel()")
    list("Shift<Key>8"	"schHiHiliteLabel(\"instance\" \"off\")")
    list("Shift<Key>;"	"hiGetCurrentWindow()->drawGridOn=t 				hiGetCurrentWindow()->drawDottedGridOn=t ")
    list("Shift<Key>A"	"geSingleSelectBox()")
     list("Shift<Key>C"	"sevOpenCalculator()")
    list("Shift<Key>D"	"geSubSelectBox()")
    list("Shift<Key>E"	"schHiDescendEdit()")
    list("Shift<Key>F"	"hiGetCurrentWindow()->stopLevel = 20")
    list("Shift<Key>F11"	"deToggleAssistants() deToggleToolbars()")
    list("Shift<key>F10"	"TIspiceNetlistAndRun(sevSession(getCurrentWindow()))")
    list("Shift<Key>F4"	"geToggleAreaSelectOption()")
    list("Shift<key>F6"	"XLCloseDataOpenData()")
    list("Shift<Key>G"	"descend_toggle()")
    list("<Key>h" "schHiEditInPlace()")
    ;list("Shift<Key>H"	"schHiHiliteLabel(\"wire\" \"off\")")
    list("Shift<Key>L"	"schHiCreateNoteLabel()")
    list("Shift<Key>M"	"schHiMove()")
    list("Shift<Key>N"	"schHiCreateNoteLabel()")
    list("Shift<Key>O"	"schHiEditorOptions()")
    list("Shift<Key>Q"	"schHiCellViewProperty()"	"schHiCellViewProperty()")
 ;   list("Shift<Key>R"	""	"schSetEnv(\"sideways\" t)")
   list("Shift<Key>R"	"awvRedisplayWindow(awvGetCurrentWindow())")
    list("Shift<Key>S"	"_schHiSave()")
    list("Shift<Key>T"	"schHiTree()")
    list("Shift<Key>U"	"hiRedo()")
    list("Shift<Key>V"	"_deToggleAssistant(\"World View\")")
    list("Shift<Key>W"	"schHiCreateWire(schGetEnv(\"defWideWireWidth\"))")
    list("Shift<Key>X"	"schHiCheckAndSave()")
    list("Shift<Key>Z"	"hiZoomRelativeScale(hiGetCurrentWindow() 0.5)")
))

hiSetBindKeys( "Layout" list(
    ;list("Ctrl Shift<Key>v" "leFinishWire()")
    list("Ctrl Shift<Key>S"	"SosEditorMenuCB(\"SosCheckInItem\")")
    list("Ctrl Shift<Key>V"	"SosEditorMenuCB(\"SosHistoryItem\")")
    list("Ctrl Shift<Key>X"	"SosEditorMenuCB(\"SosCancelCheckOutItem\")")
    list("Ctrl Shift<Key>Z"	"hiNextWinView(hiGetCurrentWindow())")
    list("Shift<Key>f" "hiZoomAbsoluteScale(hiGetCurrentWindow() 1.0)")
    list("Ctrl Shift<Key>d" "leHiP2P()")
    list("<Key>Down" "geScroll(nil \"s\"\tnil)")
    ;list("Ctrl Shift<Key>z" "leWECycleControlWire()")
    list("<Key>F9" "hiMakerHelp(strcat(getShellEnvVar(\"FT_HOME\")     \"/doc/help/gsm/bindkeys/overview\") \"firstpage\")")
    list("<Key>1" "leSetAllLayerSelectable(t)" "drdEnablePixelThreshold(!drdIsPixelThresholdEnabled())")
    list("Shift<Key>1" "leHiUnmarkNetAll()")
    list("Ctrl Shift<Key>w" "leHiCreateWire()")
    list("<Key>`" "FT_cppTriggerCallbacks()" "drdToggleSmartSnapMode()")
    list("Shift<Key>m" "leHiMerge()")
    list("<Key>o" "leHiEditDisplayOptions()")
    list("<Key>8" "geDeleteNetProbe()")
    list("Ctrl Shift<Key>t" "drdCompactSelSet('target)")
    list("Shift<Key>R9" "leMoveCursor( legRpDelta  legRpDelta)")
    list("Shift<Key>b" "geReturnToLevel()")
    list("<Key>space" "leHiAddWireVia(hiGetCurrentWindow())" "leSpaceBarFunc(hiGetCurrentWindow() t)")
    ;list("Shift<Key>g" "leHiCreateGuardRing()")
    list("Shift<Key>g" "deInstallApp(getCurrentWindow() \"VLS-GXL\")")
    list("<Key>p" "leHiCreatePath()")
    list("Ctrl<Key>Left" "geScroll(nil \"w\"\tt)")
    list("None<Btn2Down>" "hiRepeat()" "cmdOption()")
    list("<DrawThru1>" "leSelBoxOrStretch()" "geSingleSelectBox()")
    list("<Key>+" "leIncrementStopLevelByOne(hiGetCurrentWindow())")
    list("Ctrl<Key>R13" "geScroll(nil \"sw\"\tt)")
    list("Ctrl<Key>6" "FT_leEdgeAddAll()")
    list("<Key>u" "hiUndo()")
    list("<Key>n" "hiRedraw()")
    list("Ctrl<Key>R7" "geScroll(nil \"nw\"\tt)")
    list("<Key>g" "leToggleGravity()")
    list("Ctrl<Key>t" "leHiTree()")
    list("<Key>R9" "geScroll(nil \"ne\"\tnil)")
    ;list("Ctrl Shift<Key>s" "leHiGuidedRouting()")
    list("Ctrl<Key>o" "geSelectViaPile()")
    list("<Key>=" "cctlayaddtobanner()")
    list("Shift<Btn5Down>" "geScroll(nil \"e\" nil)")
    ;list("<Key>6" "FT_leEdgeAdd()")
    list("<Key>6"	"customizeOpen()")
    list("Ctrl<Key>R9" "geScroll(nil \"ne\"\tt)")
    list("Ctrl<Key>q" "FT_utilEditCommonCdfProps()")
    list("None<Btn4Down>" "geScroll(nil \"n\" nil)" "weScrollOrCycleUpWireViaAlignment()")
    list("<Key>i" "leHiCreateInst()")
    ;list("Ctrl Shift<Key>x" "leHiCreateBus()")
    list("Ctrl Shift<Key>c" "_weCycleAutoDropViaSolution(hiGetCurrentWindow())")
    list("Ctrl<Key>R11" "geScroll(nil \"\"\tt)")
    list("None<Btn3Down>" "_lxHiMousePopUp()" "_lxHiMousePopUp()")
    list("Shift<Key>space" nil "leSpaceBarFunc(hiGetCurrentWindow() t t)")
    list("<Key>Delete" "leHiDelete()" "leHiDelete()")
    list("Shift<Key>." "window(tmGetWindowNum(hiGetCurrentWindow()))->drawDottedGridOn = nil")
    list("Ctrl<Key>b" "leBalloonToggleOnOff()")
    list("Shift<Key>R11" "leMoveCursorToRefPoint()")
    list("<Key>backslash" "FT_PGtext()")
    list("<Key>KP_Equal" "legRpDelta = 0.5")
    list("<Key>KP_Add" "leHiSetRefPoint()")
    ;list("Shift<Key>s" "geSubSelectBox()")
    list("Shift<Key>s" "leHiSearch()")
    list("Shift<Key>F4" "geToggleAreaSelectOption()")
    list("Shift<Key>6" "FT_leEdgeAddArea()")
    list("<Key>Left" "geScroll(nil \"w\"\tnil)")
    list("<Key>'" "hiUpdateMagOptions()")
    ;list("Ctrl<Key>s" "geDeselectAllFig()")
    list("Ctrl<Key>s" "leHiSaveACopy(hiGetCurrentWindow())" "hiToggleEnterForm()")
    list("Ctrl Shift<Key>B"	"_leChangeEditMode(\"a\")")
    list("<Key>w" "leHiCreateWire()")
    list("<Key>KP_Divide" "legRpDelta = 1.0" "drdAddTarget()")
    list("Ctrl Shift<Btn4Down>" nil "weScaleMagnifierOrIncreaseWidth()")
    list("<Key>9" "hiDeiconifyWindow(hiGetCIWindow()) hiRaiseWindow(hiGetCIWindow())")
    list("Ctrl Shift<Key>g" "weGatherBusWires(hiGetCurrentWindow())")
    list("Shift<Key>Down" "leMoveCursor(0           -legRpDelta)")
    list("Ctrl Shift<Key>Down" "hiScaleMagnifier(0.80)")
    list("Shift<Key>u" "hiRedo()")
    list("<Key>R11" "geScroll(nil \"\"\tnil)")
    list("<Key>R4" "legRpDelta = 0.5")
    list("<Key>v" "hiPrevWinView(hiGetCurrentWindow())")
    list("Return" nil "mouseApplyOrFinishPoint()")
    list("Shift<Key>o" "leHiEditEditorOptions()")
    list("<DrawThru3>" "hiZoomIn()" "hiZoomIn()")
    list("Ctrl Shift<Btn2Down>" "hiZoomOutMagnifier(hiGetCurrentWindow())")
    list("Shift<Key>n" "leGetCoordinateForm()")
    list("<Key>F2" "geSave()")
    list("Ctrl<Key>space" "(leWECycleSnap)" "leSpaceBarFunc(hiGetCurrentWindow() \"cancel\")")
    list("Shift<Btn2Down>" "" "cmdShiftOption()")
    list("<Key>/" "hiFocusToCIW(hiGetCurrentWindow())")
    list("Ctrl<Key>z" "FT_utilIconifyAllWindows()")
    list("Ctrl<Key>l" nil "weCWHoldWidth()")
    list("Ctrl Shift<Key>u" "drdCompactSelSet('top)")
    list("<Key>KP_Enter" "mouseAddPt()")
    list("Ctrl Shift<Btn1Down>" "hiZoomInMagnifier(hiGetCurrentWindow())")
    list("Ctrl<Btn4Down>" "hiZoomInAtMouse()")
    list("Shift<Key>c" "leHiChop()")
    list("<Key>y" "leSetFormSnapMode(\"orthogonal\")")
    list("Ctrl<Key>i" "leHiCreatePin()")
    ;list("Ctrl<Key>w" "geSave()")
    list("Ctrl<Key>w" "leCloseWindow()")
    list("Shift<Key>w" "hiNextWinView(hiGetCurrentWindow())")
    list("Ctrl<Key>Tab" "hiLowerWindow(hiGetCurrentWindow())")
    list("<Key>0" "leSetAllLayerSelectable(nil)")
    list("Ctrl<Key>x" "leSetEnv(\"orientation\" \"MX\")")
    list("Ctrl Shift<Key>space" "(leWENoSnap)" "leSpaceBarFunc(hiGetCurrentWindow() \"ctrlShift\")")
    list("<Key>c" "leHiCopy()")
    list("<Key>Up" "geScroll(nil \"n\"\tnil)")
    list("Shift<Key>q" "leEditDesignProperties()")
    list("<Key>F10" "ddsHiRefresh(t)")
    list("Ctrl<Key>g" "geZoomToGrid(hiGetCurrentWindow())")
    list("<Key>BackSpace" "deletePoint()" "deletePoint()")
    list("<Key>Escape" nil "cancelEnterFun()")
    list("<Key>F3" "leHiSaveACopy(hiGetCurrentWindow())" "hiToggleEnterForm()")
    list("<Key>R6" "legRpDelta = 2.0")
    list("Shift<Key>Up" "leMoveCursor(          0  legRpDelta)")
    list("<Key>h" "leHiEditInPlace()")
    list("<Key>l" "leHiCreateLabel()")
    list("<Key>d" "leHiDescend()")
    list("Shift<Key>v" "hiNextWinView(hiGetCurrentWindow())")
    list("Ctrl<Key>v" "hiFocusToCIW(hiGetCurrentWindow())")
    list("<Key>f" "hiZoomAbsoluteScale(hiGetCurrentWindow() 0.9)")
    list("Shift<Key>i" "leHiSummary()")
    list("<Key>m" "leHiStretch()")
    list("<Key>#" "hiToggleAnchorMagnifier()")
    list("Ctrl<Key>F11" "deToggleToolbars()")
    ;list("Shift<Key>9" "hiIconifyWindow(hiGetCIWindow())")
    list("Shift<Key>9" "leHiMarkNet()")
    list("Shift<Key>0" "leHiUnmarkNet()")
    list("Ctrl<Btn5Down>" "hiZoomOutAtMouse()")
    list("Ctrl<Key>y" "leSetFormSnapMode(\"anyAngle\")")
    list("<Key>R7" "geScroll(nil \"nw\"\tnil)")
    ;list("<Key>]" "leConvertIBToDSIB()")
    list("Shift<Key>p" "leHiCreatePolygon()")
    list("<Key>R15" "geScroll(nil \"se\"\tnil)")
    list("Shift<Key>R7" "leMoveCursor(-legRpDelta  legRpDelta)")
    list("Shift<DrawThru3>" "hiZoomOut()" "hiZoomOut()")
    list("Ctrl<DrawThru1>" "geSubSelectBox()" "geSubSelectBox()")
    list("Ctrl<Key>n" "leSetFormSnapMode(\"L90XFirst\")")
    ;list("Ctrl<Key>d" "geDeselectAllFig()")
    list("Ctrl<Key>d" "CCSToggleDimming()")
    ;list("Ctrl<Key>e" "FT_fwDesignOpen(2 list(\"layout\"))")
    list("<Key>2" "hiZoomRelativeScale(hiGetCurrentWindow() 2.0)")
    list("<Key>]" "hiZoomRelativeScale(hiGetCurrentWindow() 2.0)")
    list("Ctrl Shift<Key>Up" "hiScaleMagnifier(1.25)")
    list("Shift<Key>a" "geAddSelectBox()")
    list("Shift<Key>3"	"ddsOpenLibManager()")
    list("<Key>3" "leSetAllLayerVisible( t ) leSetAllLayerSelectable( t ) leSetInstSelectable( t ) geDeselectAll() auProbeRemoveAll() leSetEntryLayer(\"background\") hiRedraw()")
    list("<Key>R5" "legRpDelta = 1.0")
    ;list("Shift<Key>x" "leSetEnv(\"orientation\" \"MY\")")
    list("Shift<Key>x" "deInstallApp(getCurrentWindow() \"Virtuoso XL\")")
    list("Shift<Key>z" "FT_utilDeiconifyAllWindows()")
    list("<Key>j" "geSelObjectsPartiallySelected()")
    list("Shift<Key>F11" "deToggleToolbars() deToggleAssistants()")
    list("Shift<Key>`" "FT_cppLibSchTriggerCallbacks(geGetEditCellView()~>libName)")
    list("<Key>." "window(tmGetWindowNum(hiGetCurrentWindow()))->drawDottedGridOn = t")
    list("<Key>t" "FT_leTamp()")
    list("<Key>R13" "geScroll(nil \"sw\"\tnil)")
    list("Shift<Key>k" "leHiClearRuler()")
    list("<Key>-" "leHiClearRuler()")
    list("None<Btn1Down>" "mouseSingleSelectPt()" "mouseAddPt(t)")
    list("<Key>s" "geSubSelectPoint()")
    list("Ctrl<Key>k" "hiCloseWindow(hiGetCurrentWindow())")
    list("<Key>F1" "hiHelp('window deGetAppInfo(deGetEditViewType(hiGetCurrentWindow()))->appName)")
    list("<DrawThru2>" "hiDynamicPanGrabbing()" "_cmdOptionDrawThru2()")
    list("Shift<Key><" "hiGetCurrentWindow()->stopLevel = 0")
    list("Shift<Key>d" "leHiDelete()")
    list("Ctrl Shift<Key>k" "leHiClearRulerInHier()")
    list("Ctrl Shift<Key>q" "leHiAddWireVia(hiGetCurrentWindow() \"up\")")
    list("Shift<Key>R13" "leMoveCursor(-legRpDelta -legRpDelta)")
    list("Ctrl<Btn1Down>" "mouseSubSelectPt()" "mouseSubSelectPt()")
    list("Shift<Btn1Down>" "mouseAddSelectPt()" "mouseAddSelectPt()")
    list("Ctrl Shift<Key>j" "drdCompactSelSet('right)")
    list("<Key>KP_Subtract" "leSetRefPointInactive(geGetEditCellView())")
    list("Ctrl Shift<Key>a" "leHiAddWireVia(hiGetCurrentWindow() \"down\")")
    list("<Key>x" "leSetEnv(\"orientation\" \"R90\")")
    list("Ctrl<Key>j" "win=getCurrentWindow() win->filterSize=if(win->filterSize==0 3.0 0.0) hiRedraw()")
    list("<Key>Right" "geScroll(nil \"e\"\tnil)")
    list("Shift<Key>8" "ivProbeRemoveDevOrNet()")
    list("Shift<Key>e" "geHiExplainMarker()")
    list("<Key>KP_Multiply" "legRpDelta = 2.0" "drdRemoveTarget()")
    ;list("<Key>e" "leHiMove()")
    list("<Key>e" "leHiDescend(hiGetCurrentWindow() \"read\")")
    list("Ctrl<Key>f" "FT_cppExplodeObject(selectedSet())")
    list("<Key>F7" "FT_cppLayPlace()")
    list("Shift<Key>r" "leHiCreateRuler()")
    list("Ctrl<Key>p" "leHiCreateChoiceOfPin()")
    list("Ctrl<Key>a" "geSelectAllFig()")
    list("Ctrl Shift<Btn5Down>" nil "weScaleMagnifierOrDecreaseWidth()")
    list("Ctrl Shift<Key>n" "drdCompactSelSet('bottom)")
    list("<Key>a" "geAddSelectPoint()")
    list("None<Btn1Down>(2)" "leDoubleClick()" "mouseApplyOrFinishPoint()")
    list("<Key>b" "geReturn()")
    list("<Key>comma" "hiGetCurrentWindow()->stopLevel = 20")
    list("<Key>Tab" "hiPan()" "leSetFocusToEditableFieldsInStatusToolbar(hiGetCurrentWindow())")
    list("None<Btn3Down>(2)" "leHiEditProp()" "hiToggleEnterForm()")
    list("None<Btn5Down>" "geScroll(nil \"s\" nil)" "weScrollOrCycleDownWireViaAlignment()")
    list("Ctrl<Btn2Down>" nil "cmdCtrlOption()")
    list("Shift<Key>F5" "leFullSelectFigOfSelSet()")
    list("<Key>4" "FT_utilDeleteChangedLayer(geGetEditCellView())")
    list("Ctrl<Key>h" "geDSAFreeze(hiGetCurrentWindow()  hiGetPoint(hiGetCurrentWindow()))")
    list("Shift<Key>4" "geDeleteAllMarker(geGetEditCellView())")
    list("Ctrl<Key>r" "leHiReShape()")
    list("<Key>F5" "deOpen()")
    list("<Key>r" "leHiCreateRect()")
    list("<Key>F6" "leToggleMaintainConnections()")
    list("Shift<Key>R15" "leMoveCursor( legRpDelta -legRpDelta)")
    list("Shift<Btn4Down>" "geScroll(nil \"w\" nil)")
    list("Ctrl<Key>Down" "geScroll(nil \"s\"\tt)")
    list("Ctrl Shift<Key>f" "leFinishEntireNet()")
    list("<Key>z" "hiZoomIn()")
    list("<Key>F4" "geTogglePartialSelect()")
    list("Ctrl Shift<Key>h" "drdCompactSelSet('left)")
    list("<Key>q" "leHiEditProp()")
    list("Ctrl<Key>Up" "geScroll(nil \"n\"\tt)")
    list("<Key>F11" "deToggleAssistants()")
    list("Shift<Key>Left" "leMoveCursor(-legRpDelta           0)")
    list("Ctrl<Key>Right" "geScroll(nil \"e\"\tt)")
    list("Shift<Key>Right" "leMoveCursor( legRpDelta           0)")
    list("Shift<DrawThru1>" "geAddSelectBox()" "geAddSelectBox()")
    list("<Key>k" "leHiMakeCell()")
    list("Ctrl<Key>R15" "geScroll(nil \"se\"\tt)")
    list("Shift<Key>y" "leSetFormSnapMode(\"diagonal\")")
    list("<Key>5" "hiZoomRelativeScale(hiGetCurrentWindow() 0.5)")
    list("<Key>[" "hiZoomRelativeScale(hiGetCurrentWindow() 0.5)")
    list("Shift<Key>t" "leHiLayerTap()")
))
